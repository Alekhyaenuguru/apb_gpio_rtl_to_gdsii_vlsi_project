* APB GPIO LVS schematic reference
.include "/home/vsduser/VLSI/ciel-pdk/ciel/sky130/versions/1e3554706ddbb2529193bdabbc7128296f3cb44a/sky130A/libs.ref/sky130_fd_sc_hd/spice/sky130_fd_sc_hd.spice"
.include "/home/vsduser/APB_GPIO_VLSI/physical_design/lvs/apb_gpio_reference_lvs_subckt_pwr_noconb_test.spice"
