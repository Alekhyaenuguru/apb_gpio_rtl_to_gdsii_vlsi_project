* Extracted by KLayout with SKY130 LVS runset on : 24/10/2026 13:54

.SUBCKT apb_gpio
X$1
+ PRDATA[10]|PRDATA[12]|PRDATA[13]|PRDATA[15]|PRDATA[16]|PRDATA[17]|PRDATA[18]|PRDATA[19]|PRDATA[21]|PRDATA[23]|PRDATA[27]|PRDATA[28]|PRDATA[29]|PRDATA[31]|PRDATA[9]|PSLVERR
+ PRESETn gpio_oe[0] \$78 \$153 \$70 \$70 sky130_fd_sc_hd__dfrtp_1
X$2
+ PRDATA[10]|PRDATA[12]|PRDATA[13]|PRDATA[15]|PRDATA[16]|PRDATA[17]|PRDATA[18]|PRDATA[19]|PRDATA[21]|PRDATA[23]|PRDATA[27]|PRDATA[28]|PRDATA[29]|PRDATA[31]|PRDATA[9]|PSLVERR
+ PRESETn gpio_oe[6] \$78 \$280 \$70 \$70 sky130_fd_sc_hd__dfrtp_1
X$3
+ PRDATA[10]|PRDATA[12]|PRDATA[13]|PRDATA[15]|PRDATA[16]|PRDATA[17]|PRDATA[18]|PRDATA[19]|PRDATA[21]|PRDATA[23]|PRDATA[27]|PRDATA[28]|PRDATA[29]|PRDATA[31]|PRDATA[9]|PSLVERR
+ PRESETn gpio_oe[7] \$346 \$451 \$70 \$70 sky130_fd_sc_hd__dfrtp_1
X$4
+ PRDATA[10]|PRDATA[12]|PRDATA[13]|PRDATA[15]|PRDATA[16]|PRDATA[17]|PRDATA[18]|PRDATA[19]|PRDATA[21]|PRDATA[23]|PRDATA[27]|PRDATA[28]|PRDATA[29]|PRDATA[31]|PRDATA[9]|PSLVERR
+ PRESETn gpio_oe[3] \$78 \$84 \$70 \$70 sky130_fd_sc_hd__dfrtp_1
X$5
+ PRDATA[10]|PRDATA[12]|PRDATA[13]|PRDATA[15]|PRDATA[16]|PRDATA[17]|PRDATA[18]|PRDATA[19]|PRDATA[21]|PRDATA[23]|PRDATA[27]|PRDATA[28]|PRDATA[29]|PRDATA[31]|PRDATA[9]|PSLVERR
+ PRESETn gpio_out[1] \$78 \$204 \$70 \$70 sky130_fd_sc_hd__dfrtp_1
X$6
+ PRDATA[10]|PRDATA[12]|PRDATA[13]|PRDATA[15]|PRDATA[16]|PRDATA[17]|PRDATA[18]|PRDATA[19]|PRDATA[21]|PRDATA[23]|PRDATA[27]|PRDATA[28]|PRDATA[29]|PRDATA[31]|PRDATA[9]|PSLVERR
+ PRESETn gpio_out[5] \$346 \$395 \$70 \$70 sky130_fd_sc_hd__dfrtp_1
X$7
+ PRDATA[10]|PRDATA[12]|PRDATA[13]|PRDATA[15]|PRDATA[16]|PRDATA[17]|PRDATA[18]|PRDATA[19]|PRDATA[21]|PRDATA[23]|PRDATA[27]|PRDATA[28]|PRDATA[29]|PRDATA[31]|PRDATA[9]|PSLVERR
+ PRESETn gpio_out[3] \$78 \$132 \$70 \$70 sky130_fd_sc_hd__dfrtp_1
X$8 PRESETn VIA_M1M2_PR
X$9 PRESETn VIA_M1M2_PR
X$10 PRESETn VIA_M1M2_PR
X$11
+ PRDATA[10]|PRDATA[12]|PRDATA[13]|PRDATA[15]|PRDATA[16]|PRDATA[17]|PRDATA[18]|PRDATA[19]|PRDATA[21]|PRDATA[23]|PRDATA[27]|PRDATA[28]|PRDATA[29]|PRDATA[31]|PRDATA[9]|PSLVERR
+ PRESETn gpio_out[7] \$346 \$431 \$70 \$70 sky130_fd_sc_hd__dfrtp_1
X$12 PRESETn VIA_M1M2_PR
X$13 PRESETn VIA_M1M2_PR
X$14
+ PRDATA[10]|PRDATA[12]|PRDATA[13]|PRDATA[15]|PRDATA[16]|PRDATA[17]|PRDATA[18]|PRDATA[19]|PRDATA[21]|PRDATA[23]|PRDATA[27]|PRDATA[28]|PRDATA[29]|PRDATA[31]|PRDATA[9]|PSLVERR
+ PRESETn gpio_oe[5] \$346 \$434 \$70 \$70 sky130_fd_sc_hd__dfrtp_1
X$15 PRESETn VIA_M1M2_PR
X$16
+ PRDATA[10]|PRDATA[12]|PRDATA[13]|PRDATA[15]|PRDATA[16]|PRDATA[17]|PRDATA[18]|PRDATA[19]|PRDATA[21]|PRDATA[23]|PRDATA[27]|PRDATA[28]|PRDATA[29]|PRDATA[31]|PRDATA[9]|PSLVERR
+ PRESETn gpio_out[4] \$346 \$479 \$70 \$70 sky130_fd_sc_hd__dfrtp_1
X$17 PRESETn VIA_M1M2_PR
X$18
+ PRDATA[10]|PRDATA[12]|PRDATA[13]|PRDATA[15]|PRDATA[16]|PRDATA[17]|PRDATA[18]|PRDATA[19]|PRDATA[21]|PRDATA[23]|PRDATA[27]|PRDATA[28]|PRDATA[29]|PRDATA[31]|PRDATA[9]|PSLVERR
+ PRESETn gpio_oe[4] \$346 \$418 \$70 \$70 sky130_fd_sc_hd__dfrtp_1
X$19 PRESETn VIA_M1M2_PR
X$20 PRESETn VIA_M1M2_PR
X$21
+ PRDATA[10]|PRDATA[12]|PRDATA[13]|PRDATA[15]|PRDATA[16]|PRDATA[17]|PRDATA[18]|PRDATA[19]|PRDATA[21]|PRDATA[23]|PRDATA[27]|PRDATA[28]|PRDATA[29]|PRDATA[31]|PRDATA[9]|PSLVERR
+ PRESETn gpio_out[0] \$78 \$179 \$70 \$70 sky130_fd_sc_hd__dfrtp_1
X$22 PRESETn VIA_M1M2_PR
X$23
+ PRDATA[10]|PRDATA[12]|PRDATA[13]|PRDATA[15]|PRDATA[16]|PRDATA[17]|PRDATA[18]|PRDATA[19]|PRDATA[21]|PRDATA[23]|PRDATA[27]|PRDATA[28]|PRDATA[29]|PRDATA[31]|PRDATA[9]|PSLVERR
+ PRESETn gpio_out[6] \$78 \$215 \$70 \$70 sky130_fd_sc_hd__dfrtp_1
X$24 PRESETn VIA_M1M2_PR
X$25 PRESETn VIA_M1M2_PR
X$26 PRESETn VIA_M1M2_PR
X$27
+ PRDATA[10]|PRDATA[12]|PRDATA[13]|PRDATA[15]|PRDATA[16]|PRDATA[17]|PRDATA[18]|PRDATA[19]|PRDATA[21]|PRDATA[23]|PRDATA[27]|PRDATA[28]|PRDATA[29]|PRDATA[31]|PRDATA[9]|PSLVERR
+ PRESETn gpio_oe[1] \$78 \$182 \$70 \$70 sky130_fd_sc_hd__dfrtp_1
X$28 PRESETn VIA_M1M2_PR
X$29 PRESETn VIA_M1M2_PR
X$30
+ PRDATA[10]|PRDATA[12]|PRDATA[13]|PRDATA[15]|PRDATA[16]|PRDATA[17]|PRDATA[18]|PRDATA[19]|PRDATA[21]|PRDATA[23]|PRDATA[27]|PRDATA[28]|PRDATA[29]|PRDATA[31]|PRDATA[9]|PSLVERR
+ PRESETn gpio_out[2] \$346 \$392 \$70 \$70 sky130_fd_sc_hd__dfrtp_1
X$31 PRESETn VIA_M1M2_PR
X$32
+ PRDATA[10]|PRDATA[12]|PRDATA[13]|PRDATA[15]|PRDATA[16]|PRDATA[17]|PRDATA[18]|PRDATA[19]|PRDATA[21]|PRDATA[23]|PRDATA[27]|PRDATA[28]|PRDATA[29]|PRDATA[31]|PRDATA[9]|PSLVERR
+ PRESETn gpio_oe[2] \$346 \$335 \$70 \$70 sky130_fd_sc_hd__dfrtp_1
X$33 PRESETn VIA_M1M2_PR
X$34 PRESETn VIA_M1M2_PR
X$35 PRESETn VIA_M1M2_PR
X$36 gpio_out[0] VIA_M1M2_PR
X$37 gpio_out[0] VIA_M1M2_PR
X$38 gpio_out[0] VIA_M1M2_PR
X$39 gpio_out[0] VIA_L1M1_PR_MR
X$40 gpio_out[0] VIA_L1M1_PR_MR
X$41 gpio_out[0] VIA_L1M1_PR_MR
X$42 \$70 gpio_out[0] \$70 \$89 \$126 gpio_oe[0]
+ PRDATA[10]|PRDATA[12]|PRDATA[13]|PRDATA[15]|PRDATA[16]|PRDATA[17]|PRDATA[18]|PRDATA[19]|PRDATA[21]|PRDATA[23]|PRDATA[27]|PRDATA[28]|PRDATA[29]|PRDATA[31]|PRDATA[9]|PSLVERR
+ \$101 sky130_fd_sc_hd__a22oi_1
X$43 gpio_out[0] VIA_L1M1_PR_MR
X$44
+ PRDATA[10]|PRDATA[12]|PRDATA[13]|PRDATA[15]|PRDATA[16]|PRDATA[17]|PRDATA[18]|PRDATA[19]|PRDATA[21]|PRDATA[23]|PRDATA[27]|PRDATA[28]|PRDATA[29]|PRDATA[31]|PRDATA[9]|PSLVERR
+ \$148 gpio_out[0] PWDATA[0] \$147 \$70 \$70 sky130_fd_sc_hd__mux2_4
X$45 PRDATA[0] VIA_M1M2_PR
X$46 PRDATA[0] VIA_L1M1_PR_MR
X$47 \$70 \$70 \$117 PRDATA[0] \$89
+ PRDATA[10]|PRDATA[12]|PRDATA[13]|PRDATA[15]|PRDATA[16]|PRDATA[17]|PRDATA[18]|PRDATA[19]|PRDATA[21]|PRDATA[23]|PRDATA[27]|PRDATA[28]|PRDATA[29]|PRDATA[31]|PRDATA[9]|PSLVERR
+ \$72 sky130_fd_sc_hd__a21oi_2
X$48 gpio_in[0] VIA_M1M2_PR
X$49 gpio_in[0] VIA_M1M2_PR
X$50 gpio_in[0] VIA_L1M1_PR_MR
X$51 \$70 \$70 \$117 gpio_in[0]
+ PRDATA[10]|PRDATA[12]|PRDATA[13]|PRDATA[15]|PRDATA[16]|PRDATA[17]|PRDATA[18]|PRDATA[19]|PRDATA[21]|PRDATA[23]|PRDATA[27]|PRDATA[28]|PRDATA[29]|PRDATA[31]|PRDATA[9]|PSLVERR
+ \$56 \$69 sky130_fd_sc_hd__o21ai_0
X$52 gpio_in[0] VIA_M1M2_PR
X$53 PRDATA[6] VIA_M1M2_PR
X$54 PRDATA[6] VIA_L1M1_PR_MR
X$55 \$70 \$70 \$76 PRDATA[6] \$245
+ PRDATA[10]|PRDATA[12]|PRDATA[13]|PRDATA[15]|PRDATA[16]|PRDATA[17]|PRDATA[18]|PRDATA[19]|PRDATA[21]|PRDATA[23]|PRDATA[27]|PRDATA[28]|PRDATA[29]|PRDATA[31]|PRDATA[9]|PSLVERR
+ \$72 sky130_fd_sc_hd__a21oi_2
X$56 gpio_in[6] VIA_M1M2_PR
X$57 gpio_in[6] VIA_L1M1_PR_MR
X$58 \$70 \$70 \$76 gpio_in[6]
+ PRDATA[10]|PRDATA[12]|PRDATA[13]|PRDATA[15]|PRDATA[16]|PRDATA[17]|PRDATA[18]|PRDATA[19]|PRDATA[21]|PRDATA[23]|PRDATA[27]|PRDATA[28]|PRDATA[29]|PRDATA[31]|PRDATA[9]|PSLVERR
+ \$56 \$69 sky130_fd_sc_hd__o21ai_0
X$59 PADDR[2] VIA_M1M2_PR
X$60 PADDR[2] VIA_L1M1_PR_MR
X$61 \$70
+ PRDATA[10]|PRDATA[12]|PRDATA[13]|PRDATA[15]|PRDATA[16]|PRDATA[17]|PRDATA[18]|PRDATA[19]|PRDATA[21]|PRDATA[23]|PRDATA[27]|PRDATA[28]|PRDATA[29]|PRDATA[31]|PRDATA[9]|PSLVERR
+ \$56 \$70 PADDR[2] sky130_fd_sc_hd__buf_2
X$62 PWDATA[1] VIA_M1M2_PR
X$63 PWDATA[1] VIA_M1M2_PR
X$64 PWDATA[1] VIA_M1M2_PR
X$65 PWDATA[1] VIA_L1M1_PR_MR
X$66
+ PRDATA[10]|PRDATA[12]|PRDATA[13]|PRDATA[15]|PRDATA[16]|PRDATA[17]|PRDATA[18]|PRDATA[19]|PRDATA[21]|PRDATA[23]|PRDATA[27]|PRDATA[28]|PRDATA[29]|PRDATA[31]|PRDATA[9]|PSLVERR
+ \$148 gpio_out[1] PWDATA[1] \$241 \$70 \$70 sky130_fd_sc_hd__mux2_4
X$67 PWDATA[1] VIA_L1M1_PR_MR
X$68
+ PRDATA[10]|PRDATA[12]|PRDATA[13]|PRDATA[15]|PRDATA[16]|PRDATA[17]|PRDATA[18]|PRDATA[19]|PRDATA[21]|PRDATA[23]|PRDATA[27]|PRDATA[28]|PRDATA[29]|PRDATA[31]|PRDATA[9]|PSLVERR
+ \$142 PWDATA[1] gpio_oe[1] \$51 \$70 \$70 sky130_fd_sc_hd__mux2_1
X$69 PWDATA[1] VIA_L1M1_PR_MR
X$70 gpio_oe[1] VIA_M1M2_PR
X$71 gpio_oe[1] VIA_M1M2_PR
X$72 gpio_oe[1] VIA_M1M2_PR
X$73 gpio_oe[1] VIA_L1M1_PR_MR
X$74 \$70 gpio_out[1] \$70 \$135 \$126 gpio_oe[1]
+ PRDATA[10]|PRDATA[12]|PRDATA[13]|PRDATA[15]|PRDATA[16]|PRDATA[17]|PRDATA[18]|PRDATA[19]|PRDATA[21]|PRDATA[23]|PRDATA[27]|PRDATA[28]|PRDATA[29]|PRDATA[31]|PRDATA[9]|PSLVERR
+ \$101 sky130_fd_sc_hd__a22oi_1
X$75 gpio_oe[1] VIA_M1M2_PR
X$76 gpio_oe[1] VIA_L1M1_PR_MR
X$77 gpio_oe[1] VIA_L1M1_PR_MR
X$78 gpio_oe[1] VIA_M1M2_PR
X$79 gpio_in[1] VIA_M1M2_PR
X$80 gpio_in[1] VIA_M1M2_PR
X$81 gpio_in[1] VIA_M1M2_PR
X$82 gpio_in[1] VIA_L1M1_PR_MR
X$83 \$70 \$70 \$82 gpio_in[1]
+ PRDATA[10]|PRDATA[12]|PRDATA[13]|PRDATA[15]|PRDATA[16]|PRDATA[17]|PRDATA[18]|PRDATA[19]|PRDATA[21]|PRDATA[23]|PRDATA[27]|PRDATA[28]|PRDATA[29]|PRDATA[31]|PRDATA[9]|PSLVERR
+ \$56 \$69 sky130_fd_sc_hd__o21ai_0
X$84 PRDATA[1] VIA_M1M2_PR
X$85 PRDATA[1] VIA_L1M1_PR_MR
X$86 \$70 \$70 \$82 PRDATA[1] \$135
+ PRDATA[10]|PRDATA[12]|PRDATA[13]|PRDATA[15]|PRDATA[16]|PRDATA[17]|PRDATA[18]|PRDATA[19]|PRDATA[21]|PRDATA[23]|PRDATA[27]|PRDATA[28]|PRDATA[29]|PRDATA[31]|PRDATA[9]|PSLVERR
+ \$72 sky130_fd_sc_hd__a21oi_2
X$87 gpio_out[1] VIA_M1M2_PR
X$88 gpio_out[1] VIA_M1M2_PR
X$89 gpio_out[1] VIA_M1M2_PR
X$90 gpio_out[1] VIA_M1M2_PR
X$91 gpio_out[1] VIA_L1M1_PR_MR
X$92 gpio_out[1] VIA_L1M1_PR_MR
X$93 gpio_out[1] VIA_L1M1_PR_MR
X$94 gpio_oe[3] VIA_M1M2_PR
X$95 gpio_oe[3] VIA_M1M2_PR
X$96 gpio_oe[3] VIA_L1M1_PR_MR
X$97 gpio_oe[3] VIA_L1M1_PR_MR
X$98 \$70 gpio_out[3] \$70 \$151 \$126 gpio_oe[3]
+ PRDATA[10]|PRDATA[12]|PRDATA[13]|PRDATA[15]|PRDATA[16]|PRDATA[17]|PRDATA[18]|PRDATA[19]|PRDATA[21]|PRDATA[23]|PRDATA[27]|PRDATA[28]|PRDATA[29]|PRDATA[31]|PRDATA[9]|PSLVERR
+ \$101 sky130_fd_sc_hd__a22oi_1
X$99 gpio_oe[3] VIA_L1M1_PR_MR
X$100
+ PRDATA[10]|PRDATA[12]|PRDATA[13]|PRDATA[15]|PRDATA[16]|PRDATA[17]|PRDATA[18]|PRDATA[19]|PRDATA[21]|PRDATA[23]|PRDATA[27]|PRDATA[28]|PRDATA[29]|PRDATA[31]|PRDATA[9]|PSLVERR
+ \$162 PWDATA[3] gpio_oe[3] \$51 \$70 \$70 sky130_fd_sc_hd__mux2_1
X$101 gpio_oe[3] VIA_M1M2_PR
X$102 PWDATA[3] VIA_M1M2_PR
X$103 PWDATA[3] VIA_M1M2_PR
X$104 PWDATA[3] VIA_L1M1_PR_MR
X$105 PWDATA[3] VIA_L1M1_PR_MR
X$106
+ PRDATA[10]|PRDATA[12]|PRDATA[13]|PRDATA[15]|PRDATA[16]|PRDATA[17]|PRDATA[18]|PRDATA[19]|PRDATA[21]|PRDATA[23]|PRDATA[27]|PRDATA[28]|PRDATA[29]|PRDATA[31]|PRDATA[9]|PSLVERR
+ \$148 gpio_out[3] PWDATA[3] \$63 \$70 \$70 sky130_fd_sc_hd__mux2_4
X$107 gpio_out[3] VIA_M1M2_PR
X$108 gpio_out[3] VIA_M1M2_PR
X$109 gpio_out[3] VIA_M1M2_PR
X$110 gpio_out[3] VIA_L1M1_PR_MR
X$111 gpio_out[3] VIA_L1M1_PR_MR
X$112 gpio_out[3] VIA_M1M2_PR
X$113 gpio_out[3] VIA_L1M1_PR_MR
X$114 \$51 VIA_M1M2_PR
X$115 \$51 VIA_M1M2_PR
X$116 \$51 VIA_M1M2_PR
X$117 \$51 VIA_M1M2_PR
X$118 \$51 VIA_M1M2_PR
X$119 \$51 VIA_M1M2_PR
X$120 \$51 VIA_M1M2_PR
X$121 \$51 VIA_M1M2_PR
X$122 \$51 VIA_M1M2_PR
X$123 \$51 VIA_M1M2_PR
X$124 \$51 VIA_M1M2_PR
X$125 \$51 VIA_M1M2_PR
X$126 \$51 VIA_L1M1_PR_MR
X$127
+ PRDATA[10]|PRDATA[12]|PRDATA[13]|PRDATA[15]|PRDATA[16]|PRDATA[17]|PRDATA[18]|PRDATA[19]|PRDATA[21]|PRDATA[23]|PRDATA[27]|PRDATA[28]|PRDATA[29]|PRDATA[31]|PRDATA[9]|PSLVERR
+ \$75 PWDATA[0] gpio_oe[0] \$51 \$70 \$70 sky130_fd_sc_hd__mux2_1
X$128 \$51 VIA_L1M1_PR_MR
X$129 \$70 \$284 \$70
+ PRDATA[10]|PRDATA[12]|PRDATA[13]|PRDATA[15]|PRDATA[16]|PRDATA[17]|PRDATA[18]|PRDATA[19]|PRDATA[21]|PRDATA[23]|PRDATA[27]|PRDATA[28]|PRDATA[29]|PRDATA[31]|PRDATA[9]|PSLVERR
+ \$51 sky130_fd_sc_hd__buf_4
X$130 \$51 VIA_L1M1_PR_MR
X$131
+ PRDATA[10]|PRDATA[12]|PRDATA[13]|PRDATA[15]|PRDATA[16]|PRDATA[17]|PRDATA[18]|PRDATA[19]|PRDATA[21]|PRDATA[23]|PRDATA[27]|PRDATA[28]|PRDATA[29]|PRDATA[31]|PRDATA[9]|PSLVERR
+ \$435 PWDATA[4] gpio_oe[4] \$51 \$70 \$70 sky130_fd_sc_hd__mux2_1
X$132 \$51 VIA_L1M1_PR_MR
X$133 \$51 VIA_M1M2_PR
X$134 \$51 VIA_L1M1_PR_MR
X$135
+ PRDATA[10]|PRDATA[12]|PRDATA[13]|PRDATA[15]|PRDATA[16]|PRDATA[17]|PRDATA[18]|PRDATA[19]|PRDATA[21]|PRDATA[23]|PRDATA[27]|PRDATA[28]|PRDATA[29]|PRDATA[31]|PRDATA[9]|PSLVERR
+ \$465 PWDATA[7] gpio_oe[7] \$51 \$70 \$70 sky130_fd_sc_hd__mux2_1
X$136 \$51 VIA_L1M1_PR_MR
X$137
+ PRDATA[10]|PRDATA[12]|PRDATA[13]|PRDATA[15]|PRDATA[16]|PRDATA[17]|PRDATA[18]|PRDATA[19]|PRDATA[21]|PRDATA[23]|PRDATA[27]|PRDATA[28]|PRDATA[29]|PRDATA[31]|PRDATA[9]|PSLVERR
+ \$504 PWDATA[5] gpio_oe[5] \$51 \$70 \$70 sky130_fd_sc_hd__mux2_1
X$138 \$51 VIA_M1M2_PR
X$139 \$51 VIA_L1M1_PR_MR
X$140
+ PRDATA[10]|PRDATA[12]|PRDATA[13]|PRDATA[15]|PRDATA[16]|PRDATA[17]|PRDATA[18]|PRDATA[19]|PRDATA[21]|PRDATA[23]|PRDATA[27]|PRDATA[28]|PRDATA[29]|PRDATA[31]|PRDATA[9]|PSLVERR
+ \$372 PWDATA[2] gpio_oe[2] \$51 \$70 \$70 sky130_fd_sc_hd__mux2_1
X$141 \$51 VIA_L1M1_PR_MR
X$142
+ PRDATA[10]|PRDATA[12]|PRDATA[13]|PRDATA[15]|PRDATA[16]|PRDATA[17]|PRDATA[18]|PRDATA[19]|PRDATA[21]|PRDATA[23]|PRDATA[27]|PRDATA[28]|PRDATA[29]|PRDATA[31]|PRDATA[9]|PSLVERR
+ \$198 PWDATA[6] gpio_oe[6] \$51 \$70 \$70 sky130_fd_sc_hd__mux2_1
X$143 \$51 VIA_M1M2_PR
X$144 \$51 VIA_L1M1_PR_MR
X$145 PWDATA[0] VIA_M1M2_PR
X$146 PWDATA[0] VIA_M1M2_PR
X$147 PWDATA[0] VIA_L1M1_PR_MR
X$148 PWDATA[0] VIA_L1M1_PR_MR
X$149 gpio_oe[0] VIA_M1M2_PR
X$150 gpio_oe[0] VIA_M1M2_PR
X$151 gpio_oe[0] VIA_L1M1_PR_MR
X$152 gpio_oe[0] VIA_L1M1_PR_MR
X$153 gpio_oe[0] VIA_M1M2_PR
X$154 gpio_oe[0] VIA_L1M1_PR_MR
X$155 gpio_oe[0] VIA_M1M2_PR
X$156 \$56 VIA_M1M2_PR
X$157 \$56 VIA_M1M2_PR
X$158 \$56 VIA_M1M2_PR
X$159 \$56 VIA_M1M2_PR
X$160 \$56 VIA_M1M2_PR
X$161 \$56 VIA_L1M1_PR_MR
X$162 \$56 VIA_L1M1_PR_MR
X$163 \$56 VIA_L1M1_PR_MR
X$164 \$56 VIA_M1M2_PR
X$165 \$56 VIA_L1M1_PR_MR
X$166 \$70 \$70 \$213 gpio_in[3]
+ PRDATA[10]|PRDATA[12]|PRDATA[13]|PRDATA[15]|PRDATA[16]|PRDATA[17]|PRDATA[18]|PRDATA[19]|PRDATA[21]|PRDATA[23]|PRDATA[27]|PRDATA[28]|PRDATA[29]|PRDATA[31]|PRDATA[9]|PSLVERR
+ \$56 \$69 sky130_fd_sc_hd__o21ai_0
X$167 \$56 VIA_L1M1_PR_MR
X$168 \$70 \$70 \$319 gpio_in[2]
+ PRDATA[10]|PRDATA[12]|PRDATA[13]|PRDATA[15]|PRDATA[16]|PRDATA[17]|PRDATA[18]|PRDATA[19]|PRDATA[21]|PRDATA[23]|PRDATA[27]|PRDATA[28]|PRDATA[29]|PRDATA[31]|PRDATA[9]|PSLVERR
+ \$56 \$69 sky130_fd_sc_hd__o21ai_0
X$169 \$56 VIA_L1M1_PR_MR
X$170 \$70 \$313 \$70
+ PRDATA[10]|PRDATA[12]|PRDATA[13]|PRDATA[15]|PRDATA[16]|PRDATA[17]|PRDATA[18]|PRDATA[19]|PRDATA[21]|PRDATA[23]|PRDATA[27]|PRDATA[28]|PRDATA[29]|PRDATA[31]|PRDATA[9]|PSLVERR
+ \$56 \$69 sky130_fd_sc_hd__nand2_1
X$171 \$56 VIA_L1M1_PR_MR
X$172
+ PRDATA[10]|PRDATA[12]|PRDATA[13]|PRDATA[15]|PRDATA[16]|PRDATA[17]|PRDATA[18]|PRDATA[19]|PRDATA[21]|PRDATA[23]|PRDATA[27]|PRDATA[28]|PRDATA[29]|PRDATA[31]|PRDATA[9]|PSLVERR
+ PADDR[4] PADDR[5] \$56 PADDR[3] \$101 \$70 \$70 sky130_fd_sc_hd__nor4_4
X$173 \$56 VIA_M1M2_PR
X$174 \$56 VIA_L1M1_PR_MR
X$175
+ PRDATA[10]|PRDATA[12]|PRDATA[13]|PRDATA[15]|PRDATA[16]|PRDATA[17]|PRDATA[18]|PRDATA[19]|PRDATA[21]|PRDATA[23]|PRDATA[27]|PRDATA[28]|PRDATA[29]|PRDATA[31]|PRDATA[9]|PSLVERR
+ PADDR[4] PADDR[5] PADDR[3] \$126 \$56 \$70 \$70 sky130_fd_sc_hd__nor4b_4
X$176 \$56 VIA_L1M1_PR_MR
X$177 \$70
+ PRDATA[10]|PRDATA[12]|PRDATA[13]|PRDATA[15]|PRDATA[16]|PRDATA[17]|PRDATA[18]|PRDATA[19]|PRDATA[21]|PRDATA[23]|PRDATA[27]|PRDATA[28]|PRDATA[29]|PRDATA[31]|PRDATA[9]|PSLVERR
+ \$362 \$56 PADDR[5] PADDR[4] \$70 PADDR[3] sky130_fd_sc_hd__nor4b_1
X$178 \$56 VIA_L1M1_PR_MR
X$179 \$56 VIA_M1M2_PR
X$180 \$63 VIA_M1M2_PR
X$181 \$63 VIA_M1M2_PR
X$182 \$63 VIA_L1M1_PR_MR
X$183
+ PRDATA[10]|PRDATA[12]|PRDATA[13]|PRDATA[15]|PRDATA[16]|PRDATA[17]|PRDATA[18]|PRDATA[19]|PRDATA[21]|PRDATA[23]|PRDATA[27]|PRDATA[28]|PRDATA[29]|PRDATA[31]|PRDATA[9]|PSLVERR
+ \$63 \$132 \$70 \$70 sky130_fd_sc_hd__buf_6
X$184 \$63 VIA_L1M1_PR_MR
X$185 \$69 VIA_M2M3_PR
X$186 \$69 VIA_M2M3_PR
X$187 \$69 VIA_M1M2_PR
X$188 \$69 VIA_M1M2_PR
X$189 \$69 VIA_M1M2_PR
X$190 \$69 VIA_M1M2_PR
X$191 \$69 VIA_L1M1_PR_MR
X$192 \$69 VIA_L1M1_PR_MR
X$193 \$69 VIA_M1M2_PR
X$194 \$69 VIA_L1M1_PR_MR
X$195 \$69 VIA_M1M2_PR
X$196 \$69 VIA_L1M1_PR_MR
X$197 \$69 VIA_L1M1_PR_MR
X$198 \$69 VIA_L1M1_PR_MR
X$199
+ PRDATA[10]|PRDATA[12]|PRDATA[13]|PRDATA[15]|PRDATA[16]|PRDATA[17]|PRDATA[18]|PRDATA[19]|PRDATA[21]|PRDATA[23]|PRDATA[27]|PRDATA[28]|PRDATA[29]|PRDATA[31]|PRDATA[9]|PSLVERR
+ \$69 PADDR[4] PADDR[5] PADDR[3] \$70 \$70 sky130_fd_sc_hd__nor3b_2
X$200 \$69 VIA_M1M2_PR
X$201 \$69 VIA_L1M1_PR_MR
X$202 \$69 VIA_M1M2_PR
X$203 \$70 \$372 \$70
+ PRDATA[10]|PRDATA[12]|PRDATA[13]|PRDATA[15]|PRDATA[16]|PRDATA[17]|PRDATA[18]|PRDATA[19]|PRDATA[21]|PRDATA[23]|PRDATA[27]|PRDATA[28]|PRDATA[29]|PRDATA[31]|PRDATA[9]|PSLVERR
+ \$335 sky130_fd_sc_hd__buf_4
X$204 \$70 \$70
+ PRDATA[10]|PRDATA[12]|PRDATA[13]|PRDATA[15]|PRDATA[16]|PRDATA[17]|PRDATA[18]|PRDATA[19]|PRDATA[21]|PRDATA[23]|PRDATA[27]|PRDATA[28]|PRDATA[29]|PRDATA[31]|PRDATA[9]|PSLVERR
+ sky130_fd_sc_hd__fill_2
X$205 \$70 \$70
+ PRDATA[10]|PRDATA[12]|PRDATA[13]|PRDATA[15]|PRDATA[16]|PRDATA[17]|PRDATA[18]|PRDATA[19]|PRDATA[21]|PRDATA[23]|PRDATA[27]|PRDATA[28]|PRDATA[29]|PRDATA[31]|PRDATA[9]|PSLVERR
+ sky130_fd_sc_hd__fill_2
X$206 \$70
+ PRDATA[10]|PRDATA[12]|PRDATA[13]|PRDATA[15]|PRDATA[16]|PRDATA[17]|PRDATA[18]|PRDATA[19]|PRDATA[21]|PRDATA[23]|PRDATA[27]|PRDATA[28]|PRDATA[29]|PRDATA[31]|PRDATA[9]|PSLVERR
+ sky130_fd_sc_hd__tapvpwrvgnd_1
X$207 \$70 \$70
+ PRDATA[10]|PRDATA[12]|PRDATA[13]|PRDATA[15]|PRDATA[16]|PRDATA[17]|PRDATA[18]|PRDATA[19]|PRDATA[21]|PRDATA[23]|PRDATA[27]|PRDATA[28]|PRDATA[29]|PRDATA[31]|PRDATA[9]|PSLVERR
+ sky130_fd_sc_hd__fill_1
X$208 \$70 \$70 \$319 PRDATA[2] \$340
+ PRDATA[10]|PRDATA[12]|PRDATA[13]|PRDATA[15]|PRDATA[16]|PRDATA[17]|PRDATA[18]|PRDATA[19]|PRDATA[21]|PRDATA[23]|PRDATA[27]|PRDATA[28]|PRDATA[29]|PRDATA[31]|PRDATA[9]|PSLVERR
+ \$72 sky130_fd_sc_hd__a21oi_2
X$209
+ PRDATA[10]|PRDATA[12]|PRDATA[13]|PRDATA[15]|PRDATA[16]|PRDATA[17]|PRDATA[18]|PRDATA[19]|PRDATA[21]|PRDATA[23]|PRDATA[27]|PRDATA[28]|PRDATA[29]|PRDATA[31]|PRDATA[9]|PSLVERR
+ PCLK \$223 \$70 \$70 sky130_fd_sc_hd__clkbuf_16
X$210 \$70 \$70
+ PRDATA[10]|PRDATA[12]|PRDATA[13]|PRDATA[15]|PRDATA[16]|PRDATA[17]|PRDATA[18]|PRDATA[19]|PRDATA[21]|PRDATA[23]|PRDATA[27]|PRDATA[28]|PRDATA[29]|PRDATA[31]|PRDATA[9]|PSLVERR
+ sky130_fd_sc_hd__fill_4
X$211 \$70 \$70
+ PRDATA[10]|PRDATA[12]|PRDATA[13]|PRDATA[15]|PRDATA[16]|PRDATA[17]|PRDATA[18]|PRDATA[19]|PRDATA[21]|PRDATA[23]|PRDATA[27]|PRDATA[28]|PRDATA[29]|PRDATA[31]|PRDATA[9]|PSLVERR
+ sky130_fd_sc_hd__fill_1
X$212 \$70
+ PRDATA[10]|PRDATA[12]|PRDATA[13]|PRDATA[15]|PRDATA[16]|PRDATA[17]|PRDATA[18]|PRDATA[19]|PRDATA[21]|PRDATA[23]|PRDATA[27]|PRDATA[28]|PRDATA[29]|PRDATA[31]|PRDATA[9]|PSLVERR
+ sky130_fd_sc_hd__tapvpwrvgnd_1
X$213 \$70 \$70
+ PRDATA[10]|PRDATA[12]|PRDATA[13]|PRDATA[15]|PRDATA[16]|PRDATA[17]|PRDATA[18]|PRDATA[19]|PRDATA[21]|PRDATA[23]|PRDATA[27]|PRDATA[28]|PRDATA[29]|PRDATA[31]|PRDATA[9]|PSLVERR
+ sky130_fd_sc_hd__fill_4
X$214 \$70 \$70
+ PRDATA[10]|PRDATA[12]|PRDATA[13]|PRDATA[15]|PRDATA[16]|PRDATA[17]|PRDATA[18]|PRDATA[19]|PRDATA[21]|PRDATA[23]|PRDATA[27]|PRDATA[28]|PRDATA[29]|PRDATA[31]|PRDATA[9]|PSLVERR
+ sky130_fd_sc_hd__fill_1
X$215 \$70
+ PRDATA[10]|PRDATA[12]|PRDATA[13]|PRDATA[15]|PRDATA[16]|PRDATA[17]|PRDATA[18]|PRDATA[19]|PRDATA[21]|PRDATA[23]|PRDATA[27]|PRDATA[28]|PRDATA[29]|PRDATA[31]|PRDATA[9]|PSLVERR
+ \$330 PRDATA[30] \$313 \$70 sky130_fd_sc_hd__nor2_2
X$216 \$70
+ PRDATA[10]|PRDATA[12]|PRDATA[13]|PRDATA[15]|PRDATA[16]|PRDATA[17]|PRDATA[18]|PRDATA[19]|PRDATA[21]|PRDATA[23]|PRDATA[27]|PRDATA[28]|PRDATA[29]|PRDATA[31]|PRDATA[9]|PSLVERR
+ \$330 PRDATA[20] \$313 \$70 sky130_fd_sc_hd__nor2_2
X$217 \$70 \$70
+ PRDATA[10]|PRDATA[12]|PRDATA[13]|PRDATA[15]|PRDATA[16]|PRDATA[17]|PRDATA[18]|PRDATA[19]|PRDATA[21]|PRDATA[23]|PRDATA[27]|PRDATA[28]|PRDATA[29]|PRDATA[31]|PRDATA[9]|PSLVERR
+ sky130_fd_sc_hd__fill_8
X$218 \$70 \$70
+ PRDATA[10]|PRDATA[12]|PRDATA[13]|PRDATA[15]|PRDATA[16]|PRDATA[17]|PRDATA[18]|PRDATA[19]|PRDATA[21]|PRDATA[23]|PRDATA[27]|PRDATA[28]|PRDATA[29]|PRDATA[31]|PRDATA[9]|PSLVERR
+ sky130_fd_sc_hd__fill_1
X$219
+ PRDATA[10]|PRDATA[12]|PRDATA[13]|PRDATA[15]|PRDATA[16]|PRDATA[17]|PRDATA[18]|PRDATA[19]|PRDATA[21]|PRDATA[23]|PRDATA[27]|PRDATA[28]|PRDATA[29]|PRDATA[31]|PRDATA[9]|PSLVERR
+ \$148 gpio_out[2] PWDATA[2] \$393 \$70 \$70 sky130_fd_sc_hd__mux2_4
X$220 \$70 \$70
+ PRDATA[10]|PRDATA[12]|PRDATA[13]|PRDATA[15]|PRDATA[16]|PRDATA[17]|PRDATA[18]|PRDATA[19]|PRDATA[21]|PRDATA[23]|PRDATA[27]|PRDATA[28]|PRDATA[29]|PRDATA[31]|PRDATA[9]|PSLVERR
+ sky130_fd_sc_hd__fill_8
X$221 \$70 \$70
+ PRDATA[10]|PRDATA[12]|PRDATA[13]|PRDATA[15]|PRDATA[16]|PRDATA[17]|PRDATA[18]|PRDATA[19]|PRDATA[21]|PRDATA[23]|PRDATA[27]|PRDATA[28]|PRDATA[29]|PRDATA[31]|PRDATA[9]|PSLVERR
+ sky130_fd_sc_hd__fill_8
X$222 \$70 \$70
+ PRDATA[10]|PRDATA[12]|PRDATA[13]|PRDATA[15]|PRDATA[16]|PRDATA[17]|PRDATA[18]|PRDATA[19]|PRDATA[21]|PRDATA[23]|PRDATA[27]|PRDATA[28]|PRDATA[29]|PRDATA[31]|PRDATA[9]|PSLVERR
+ sky130_fd_sc_hd__fill_4
X$223 \$70 \$70
+ PRDATA[10]|PRDATA[12]|PRDATA[13]|PRDATA[15]|PRDATA[16]|PRDATA[17]|PRDATA[18]|PRDATA[19]|PRDATA[21]|PRDATA[23]|PRDATA[27]|PRDATA[28]|PRDATA[29]|PRDATA[31]|PRDATA[9]|PSLVERR
+ sky130_fd_sc_hd__fill_1
X$224 \$70
+ PRDATA[10]|PRDATA[12]|PRDATA[13]|PRDATA[15]|PRDATA[16]|PRDATA[17]|PRDATA[18]|PRDATA[19]|PRDATA[21]|PRDATA[23]|PRDATA[27]|PRDATA[28]|PRDATA[29]|PRDATA[31]|PRDATA[9]|PSLVERR
+ \$330 \$70 \$72 sky130_fd_sc_hd__buf_2
X$225 \$70 VIA_via2_3_1600_480_1_5_320_320
X$226 \$70 VIA_via3_4_1600_480_1_4_400_400
X$227 \$70 VIA_via4_5_1600_480_1_4_400_400
X$228 \$70 \$70
+ PRDATA[10]|PRDATA[12]|PRDATA[13]|PRDATA[15]|PRDATA[16]|PRDATA[17]|PRDATA[18]|PRDATA[19]|PRDATA[21]|PRDATA[23]|PRDATA[27]|PRDATA[28]|PRDATA[29]|PRDATA[31]|PRDATA[9]|PSLVERR
+ sky130_fd_sc_hd__fill_2
X$229 \$70
+ PRDATA[10]|PRDATA[12]|PRDATA[13]|PRDATA[15]|PRDATA[16]|PRDATA[17]|PRDATA[18]|PRDATA[19]|PRDATA[21]|PRDATA[23]|PRDATA[27]|PRDATA[28]|PRDATA[29]|PRDATA[31]|PRDATA[9]|PSLVERR
+ sky130_fd_sc_hd__tapvpwrvgnd_1
X$230 \$70 \$70
+ PRDATA[10]|PRDATA[12]|PRDATA[13]|PRDATA[15]|PRDATA[16]|PRDATA[17]|PRDATA[18]|PRDATA[19]|PRDATA[21]|PRDATA[23]|PRDATA[27]|PRDATA[28]|PRDATA[29]|PRDATA[31]|PRDATA[9]|PSLVERR
+ sky130_fd_sc_hd__fill_8
X$231 \$70 \$70
+ PRDATA[10]|PRDATA[12]|PRDATA[13]|PRDATA[15]|PRDATA[16]|PRDATA[17]|PRDATA[18]|PRDATA[19]|PRDATA[21]|PRDATA[23]|PRDATA[27]|PRDATA[28]|PRDATA[29]|PRDATA[31]|PRDATA[9]|PSLVERR
+ sky130_fd_sc_hd__fill_4
X$232 \$70 \$70
+ PRDATA[10]|PRDATA[12]|PRDATA[13]|PRDATA[15]|PRDATA[16]|PRDATA[17]|PRDATA[18]|PRDATA[19]|PRDATA[21]|PRDATA[23]|PRDATA[27]|PRDATA[28]|PRDATA[29]|PRDATA[31]|PRDATA[9]|PSLVERR
+ sky130_fd_sc_hd__fill_2
X$233 \$70 \$70
+ PRDATA[10]|PRDATA[12]|PRDATA[13]|PRDATA[15]|PRDATA[16]|PRDATA[17]|PRDATA[18]|PRDATA[19]|PRDATA[21]|PRDATA[23]|PRDATA[27]|PRDATA[28]|PRDATA[29]|PRDATA[31]|PRDATA[9]|PSLVERR
+ sky130_fd_sc_hd__fill_1
X$234 \$70 \$70
+ PRDATA[10]|PRDATA[12]|PRDATA[13]|PRDATA[15]|PRDATA[16]|PRDATA[17]|PRDATA[18]|PRDATA[19]|PRDATA[21]|PRDATA[23]|PRDATA[27]|PRDATA[28]|PRDATA[29]|PRDATA[31]|PRDATA[9]|PSLVERR
+ sky130_fd_sc_hd__fill_8
X$235 \$70 \$70
+ PRDATA[10]|PRDATA[12]|PRDATA[13]|PRDATA[15]|PRDATA[16]|PRDATA[17]|PRDATA[18]|PRDATA[19]|PRDATA[21]|PRDATA[23]|PRDATA[27]|PRDATA[28]|PRDATA[29]|PRDATA[31]|PRDATA[9]|PSLVERR
+ sky130_fd_sc_hd__fill_2
X$236 \$70
+ PRDATA[10]|PRDATA[12]|PRDATA[13]|PRDATA[15]|PRDATA[16]|PRDATA[17]|PRDATA[18]|PRDATA[19]|PRDATA[21]|PRDATA[23]|PRDATA[27]|PRDATA[28]|PRDATA[29]|PRDATA[31]|PRDATA[9]|PSLVERR
+ \$330 PRDATA[26] \$313 \$70 sky130_fd_sc_hd__nor2_2
X$237 \$70
+ PRDATA[10]|PRDATA[12]|PRDATA[13]|PRDATA[15]|PRDATA[16]|PRDATA[17]|PRDATA[18]|PRDATA[19]|PRDATA[21]|PRDATA[23]|PRDATA[27]|PRDATA[28]|PRDATA[29]|PRDATA[31]|PRDATA[9]|PSLVERR
+ \$330 PRDATA[22] \$313 \$70 sky130_fd_sc_hd__nor2_2
X$238 \$70 \$70
+ PRDATA[10]|PRDATA[12]|PRDATA[13]|PRDATA[15]|PRDATA[16]|PRDATA[17]|PRDATA[18]|PRDATA[19]|PRDATA[21]|PRDATA[23]|PRDATA[27]|PRDATA[28]|PRDATA[29]|PRDATA[31]|PRDATA[9]|PSLVERR
+ sky130_fd_sc_hd__fill_8
X$239 \$70 \$70
+ PRDATA[10]|PRDATA[12]|PRDATA[13]|PRDATA[15]|PRDATA[16]|PRDATA[17]|PRDATA[18]|PRDATA[19]|PRDATA[21]|PRDATA[23]|PRDATA[27]|PRDATA[28]|PRDATA[29]|PRDATA[31]|PRDATA[9]|PSLVERR
+ sky130_fd_sc_hd__fill_4
X$240 \$70 \$70
+ PRDATA[10]|PRDATA[12]|PRDATA[13]|PRDATA[15]|PRDATA[16]|PRDATA[17]|PRDATA[18]|PRDATA[19]|PRDATA[21]|PRDATA[23]|PRDATA[27]|PRDATA[28]|PRDATA[29]|PRDATA[31]|PRDATA[9]|PSLVERR
+ sky130_fd_sc_hd__fill_8
X$241 \$70 \$465 \$70
+ PRDATA[10]|PRDATA[12]|PRDATA[13]|PRDATA[15]|PRDATA[16]|PRDATA[17]|PRDATA[18]|PRDATA[19]|PRDATA[21]|PRDATA[23]|PRDATA[27]|PRDATA[28]|PRDATA[29]|PRDATA[31]|PRDATA[9]|PSLVERR
+ \$451 sky130_fd_sc_hd__buf_4
X$242
+ PRDATA[10]|PRDATA[12]|PRDATA[13]|PRDATA[15]|PRDATA[16]|PRDATA[17]|PRDATA[18]|PRDATA[19]|PRDATA[21]|PRDATA[23]|PRDATA[27]|PRDATA[28]|PRDATA[29]|PRDATA[31]|PRDATA[9]|PSLVERR
+ \$148 gpio_out[7] PWDATA[7] \$430 \$70 \$70 sky130_fd_sc_hd__mux2_4
X$243 \$70
+ PRDATA[10]|PRDATA[12]|PRDATA[13]|PRDATA[15]|PRDATA[16]|PRDATA[17]|PRDATA[18]|PRDATA[19]|PRDATA[21]|PRDATA[23]|PRDATA[27]|PRDATA[28]|PRDATA[29]|PRDATA[31]|PRDATA[9]|PSLVERR
+ sky130_fd_sc_hd__tapvpwrvgnd_1
X$244 \$70 \$70
+ PRDATA[10]|PRDATA[12]|PRDATA[13]|PRDATA[15]|PRDATA[16]|PRDATA[17]|PRDATA[18]|PRDATA[19]|PRDATA[21]|PRDATA[23]|PRDATA[27]|PRDATA[28]|PRDATA[29]|PRDATA[31]|PRDATA[9]|PSLVERR
+ sky130_fd_sc_hd__fill_8
X$245 \$70 \$70
+ PRDATA[10]|PRDATA[12]|PRDATA[13]|PRDATA[15]|PRDATA[16]|PRDATA[17]|PRDATA[18]|PRDATA[19]|PRDATA[21]|PRDATA[23]|PRDATA[27]|PRDATA[28]|PRDATA[29]|PRDATA[31]|PRDATA[9]|PSLVERR
+ sky130_fd_sc_hd__fill_1
X$246
+ PRDATA[10]|PRDATA[12]|PRDATA[13]|PRDATA[15]|PRDATA[16]|PRDATA[17]|PRDATA[18]|PRDATA[19]|PRDATA[21]|PRDATA[23]|PRDATA[27]|PRDATA[28]|PRDATA[29]|PRDATA[31]|PRDATA[9]|PSLVERR
+ \$148 gpio_out[5] PWDATA[5] \$446 \$70 \$70 sky130_fd_sc_hd__mux2_4
X$247 \$70 \$70
+ PRDATA[10]|PRDATA[12]|PRDATA[13]|PRDATA[15]|PRDATA[16]|PRDATA[17]|PRDATA[18]|PRDATA[19]|PRDATA[21]|PRDATA[23]|PRDATA[27]|PRDATA[28]|PRDATA[29]|PRDATA[31]|PRDATA[9]|PSLVERR
+ sky130_fd_sc_hd__fill_8
X$248 \$70 \$70
+ PRDATA[10]|PRDATA[12]|PRDATA[13]|PRDATA[15]|PRDATA[16]|PRDATA[17]|PRDATA[18]|PRDATA[19]|PRDATA[21]|PRDATA[23]|PRDATA[27]|PRDATA[28]|PRDATA[29]|PRDATA[31]|PRDATA[9]|PSLVERR
+ sky130_fd_sc_hd__fill_1
X$249 \$70
+ PRDATA[10]|PRDATA[12]|PRDATA[13]|PRDATA[15]|PRDATA[16]|PRDATA[17]|PRDATA[18]|PRDATA[19]|PRDATA[21]|PRDATA[23]|PRDATA[27]|PRDATA[28]|PRDATA[29]|PRDATA[31]|PRDATA[9]|PSLVERR
+ sky130_fd_sc_hd__tapvpwrvgnd_1
X$250 \$70 \$70
+ PRDATA[10]|PRDATA[12]|PRDATA[13]|PRDATA[15]|PRDATA[16]|PRDATA[17]|PRDATA[18]|PRDATA[19]|PRDATA[21]|PRDATA[23]|PRDATA[27]|PRDATA[28]|PRDATA[29]|PRDATA[31]|PRDATA[9]|PSLVERR
+ sky130_fd_sc_hd__fill_8
X$251 \$70 \$70
+ PRDATA[10]|PRDATA[12]|PRDATA[13]|PRDATA[15]|PRDATA[16]|PRDATA[17]|PRDATA[18]|PRDATA[19]|PRDATA[21]|PRDATA[23]|PRDATA[27]|PRDATA[28]|PRDATA[29]|PRDATA[31]|PRDATA[9]|PSLVERR
+ sky130_fd_sc_hd__fill_8
X$252 \$70 \$70
+ PRDATA[10]|PRDATA[12]|PRDATA[13]|PRDATA[15]|PRDATA[16]|PRDATA[17]|PRDATA[18]|PRDATA[19]|PRDATA[21]|PRDATA[23]|PRDATA[27]|PRDATA[28]|PRDATA[29]|PRDATA[31]|PRDATA[9]|PSLVERR
+ sky130_fd_sc_hd__fill_4
X$253 \$70 \$70
+ PRDATA[10]|PRDATA[12]|PRDATA[13]|PRDATA[15]|PRDATA[16]|PRDATA[17]|PRDATA[18]|PRDATA[19]|PRDATA[21]|PRDATA[23]|PRDATA[27]|PRDATA[28]|PRDATA[29]|PRDATA[31]|PRDATA[9]|PSLVERR
+ sky130_fd_sc_hd__fill_2
X$254 \$70 \$70
+ PRDATA[10]|PRDATA[12]|PRDATA[13]|PRDATA[15]|PRDATA[16]|PRDATA[17]|PRDATA[18]|PRDATA[19]|PRDATA[21]|PRDATA[23]|PRDATA[27]|PRDATA[28]|PRDATA[29]|PRDATA[31]|PRDATA[9]|PSLVERR
+ sky130_fd_sc_hd__fill_1
X$255 \$70 \$70
+ PRDATA[10]|PRDATA[12]|PRDATA[13]|PRDATA[15]|PRDATA[16]|PRDATA[17]|PRDATA[18]|PRDATA[19]|PRDATA[21]|PRDATA[23]|PRDATA[27]|PRDATA[28]|PRDATA[29]|PRDATA[31]|PRDATA[9]|PSLVERR
+ sky130_fd_sc_hd__fill_8
X$256 \$70 \$70
+ PRDATA[10]|PRDATA[12]|PRDATA[13]|PRDATA[15]|PRDATA[16]|PRDATA[17]|PRDATA[18]|PRDATA[19]|PRDATA[21]|PRDATA[23]|PRDATA[27]|PRDATA[28]|PRDATA[29]|PRDATA[31]|PRDATA[9]|PSLVERR
+ sky130_fd_sc_hd__fill_8
X$257 \$70 \$70
+ PRDATA[10]|PRDATA[12]|PRDATA[13]|PRDATA[15]|PRDATA[16]|PRDATA[17]|PRDATA[18]|PRDATA[19]|PRDATA[21]|PRDATA[23]|PRDATA[27]|PRDATA[28]|PRDATA[29]|PRDATA[31]|PRDATA[9]|PSLVERR
+ sky130_fd_sc_hd__fill_4
X$258 \$70 \$70
+ PRDATA[10]|PRDATA[12]|PRDATA[13]|PRDATA[15]|PRDATA[16]|PRDATA[17]|PRDATA[18]|PRDATA[19]|PRDATA[21]|PRDATA[23]|PRDATA[27]|PRDATA[28]|PRDATA[29]|PRDATA[31]|PRDATA[9]|PSLVERR
+ sky130_fd_sc_hd__fill_1
X$259
+ PRDATA[10]|PRDATA[12]|PRDATA[13]|PRDATA[15]|PRDATA[16]|PRDATA[17]|PRDATA[18]|PRDATA[19]|PRDATA[21]|PRDATA[23]|PRDATA[27]|PRDATA[28]|PRDATA[29]|PRDATA[31]|PRDATA[9]|PSLVERR
+ \$515 gpio_out[7] \$101 gpio_oe[7] \$126 gpio_in[7] \$362 \$70 \$70
+ sky130_fd_sc_hd__a222oi_1
X$260 \$70 VIA_via2_3_1600_480_1_5_320_320
X$261 \$70 VIA_via3_4_1600_480_1_4_400_400
X$262 \$70 \$70
+ PRDATA[10]|PRDATA[12]|PRDATA[13]|PRDATA[15]|PRDATA[16]|PRDATA[17]|PRDATA[18]|PRDATA[19]|PRDATA[21]|PRDATA[23]|PRDATA[27]|PRDATA[28]|PRDATA[29]|PRDATA[31]|PRDATA[9]|PSLVERR
+ sky130_fd_sc_hd__fill_2
X$263 \$70
+ PRDATA[10]|PRDATA[12]|PRDATA[13]|PRDATA[15]|PRDATA[16]|PRDATA[17]|PRDATA[18]|PRDATA[19]|PRDATA[21]|PRDATA[23]|PRDATA[27]|PRDATA[28]|PRDATA[29]|PRDATA[31]|PRDATA[9]|PSLVERR
+ sky130_fd_sc_hd__tapvpwrvgnd_1
X$264
+ PRDATA[10]|PRDATA[12]|PRDATA[13]|PRDATA[15]|PRDATA[16]|PRDATA[17]|PRDATA[18]|PRDATA[19]|PRDATA[21]|PRDATA[23]|PRDATA[27]|PRDATA[28]|PRDATA[29]|PRDATA[31]|PRDATA[9]|PSLVERR
+ \$505 gpio_out[5] \$101 gpio_oe[5] \$126 gpio_in[5] \$362 \$70 \$70
+ sky130_fd_sc_hd__a222oi_1
X$265 \$70 \$70
+ PRDATA[10]|PRDATA[12]|PRDATA[13]|PRDATA[15]|PRDATA[16]|PRDATA[17]|PRDATA[18]|PRDATA[19]|PRDATA[21]|PRDATA[23]|PRDATA[27]|PRDATA[28]|PRDATA[29]|PRDATA[31]|PRDATA[9]|PSLVERR
+ sky130_fd_sc_hd__fill_2
X$266 \$70 \$70
+ PRDATA[10]|PRDATA[12]|PRDATA[13]|PRDATA[15]|PRDATA[16]|PRDATA[17]|PRDATA[18]|PRDATA[19]|PRDATA[21]|PRDATA[23]|PRDATA[27]|PRDATA[28]|PRDATA[29]|PRDATA[31]|PRDATA[9]|PSLVERR
+ sky130_fd_sc_hd__fill_1
X$267 \$70 gpio_out[4] \$70 \$399 \$362 gpio_in[4]
+ PRDATA[10]|PRDATA[12]|PRDATA[13]|PRDATA[15]|PRDATA[16]|PRDATA[17]|PRDATA[18]|PRDATA[19]|PRDATA[21]|PRDATA[23]|PRDATA[27]|PRDATA[28]|PRDATA[29]|PRDATA[31]|PRDATA[9]|PSLVERR
+ \$101 sky130_fd_sc_hd__a22oi_1
X$268
+ PRDATA[10]|PRDATA[12]|PRDATA[13]|PRDATA[15]|PRDATA[16]|PRDATA[17]|PRDATA[18]|PRDATA[19]|PRDATA[21]|PRDATA[23]|PRDATA[27]|PRDATA[28]|PRDATA[29]|PRDATA[31]|PRDATA[9]|PSLVERR
+ \$453 \$479 \$70 \$70 sky130_fd_sc_hd__buf_6
X$269 \$70 \$70
+ PRDATA[10]|PRDATA[12]|PRDATA[13]|PRDATA[15]|PRDATA[16]|PRDATA[17]|PRDATA[18]|PRDATA[19]|PRDATA[21]|PRDATA[23]|PRDATA[27]|PRDATA[28]|PRDATA[29]|PRDATA[31]|PRDATA[9]|PSLVERR
+ sky130_fd_sc_hd__fill_8
X$270 \$70 \$70
+ PRDATA[10]|PRDATA[12]|PRDATA[13]|PRDATA[15]|PRDATA[16]|PRDATA[17]|PRDATA[18]|PRDATA[19]|PRDATA[21]|PRDATA[23]|PRDATA[27]|PRDATA[28]|PRDATA[29]|PRDATA[31]|PRDATA[9]|PSLVERR
+ sky130_fd_sc_hd__fill_8
X$271 \$70 \$70
+ PRDATA[10]|PRDATA[12]|PRDATA[13]|PRDATA[15]|PRDATA[16]|PRDATA[17]|PRDATA[18]|PRDATA[19]|PRDATA[21]|PRDATA[23]|PRDATA[27]|PRDATA[28]|PRDATA[29]|PRDATA[31]|PRDATA[9]|PSLVERR
+ sky130_fd_sc_hd__fill_8
X$272 \$70 \$70
+ PRDATA[10]|PRDATA[12]|PRDATA[13]|PRDATA[15]|PRDATA[16]|PRDATA[17]|PRDATA[18]|PRDATA[19]|PRDATA[21]|PRDATA[23]|PRDATA[27]|PRDATA[28]|PRDATA[29]|PRDATA[31]|PRDATA[9]|PSLVERR
+ sky130_fd_sc_hd__fill_2
X$273 \$70 \$70
+ PRDATA[10]|PRDATA[12]|PRDATA[13]|PRDATA[15]|PRDATA[16]|PRDATA[17]|PRDATA[18]|PRDATA[19]|PRDATA[21]|PRDATA[23]|PRDATA[27]|PRDATA[28]|PRDATA[29]|PRDATA[31]|PRDATA[9]|PSLVERR
+ sky130_fd_sc_hd__fill_1
X$274 \$70 VIA_via4_5_1600_480_1_4_400_400
X$275
+ PRDATA[10]|PRDATA[12]|PRDATA[13]|PRDATA[15]|PRDATA[16]|PRDATA[17]|PRDATA[18]|PRDATA[19]|PRDATA[21]|PRDATA[23]|PRDATA[27]|PRDATA[28]|PRDATA[29]|PRDATA[31]|PRDATA[9]|PSLVERR
+ \$230 \$215 \$70 \$70 sky130_fd_sc_hd__buf_6
X$276 \$70 \$70
+ PRDATA[10]|PRDATA[12]|PRDATA[13]|PRDATA[15]|PRDATA[16]|PRDATA[17]|PRDATA[18]|PRDATA[19]|PRDATA[21]|PRDATA[23]|PRDATA[27]|PRDATA[28]|PRDATA[29]|PRDATA[31]|PRDATA[9]|PSLVERR
+ sky130_fd_sc_hd__fill_1
X$277 \$70
+ PRDATA[10]|PRDATA[12]|PRDATA[13]|PRDATA[15]|PRDATA[16]|PRDATA[17]|PRDATA[18]|PRDATA[19]|PRDATA[21]|PRDATA[23]|PRDATA[27]|PRDATA[28]|PRDATA[29]|PRDATA[31]|PRDATA[9]|PSLVERR
+ sky130_fd_sc_hd__tapvpwrvgnd_1
X$278 \$70 gpio_out[6] \$70 \$245 \$126 gpio_oe[6]
+ PRDATA[10]|PRDATA[12]|PRDATA[13]|PRDATA[15]|PRDATA[16]|PRDATA[17]|PRDATA[18]|PRDATA[19]|PRDATA[21]|PRDATA[23]|PRDATA[27]|PRDATA[28]|PRDATA[29]|PRDATA[31]|PRDATA[9]|PSLVERR
+ \$101 sky130_fd_sc_hd__a22oi_1
X$279 \$70 \$70
+ PRDATA[10]|PRDATA[12]|PRDATA[13]|PRDATA[15]|PRDATA[16]|PRDATA[17]|PRDATA[18]|PRDATA[19]|PRDATA[21]|PRDATA[23]|PRDATA[27]|PRDATA[28]|PRDATA[29]|PRDATA[31]|PRDATA[9]|PSLVERR
+ sky130_fd_sc_hd__fill_8
X$280 \$70 \$70
+ PRDATA[10]|PRDATA[12]|PRDATA[13]|PRDATA[15]|PRDATA[16]|PRDATA[17]|PRDATA[18]|PRDATA[19]|PRDATA[21]|PRDATA[23]|PRDATA[27]|PRDATA[28]|PRDATA[29]|PRDATA[31]|PRDATA[9]|PSLVERR
+ sky130_fd_sc_hd__fill_2
X$281 \$70 \$70
+ PRDATA[10]|PRDATA[12]|PRDATA[13]|PRDATA[15]|PRDATA[16]|PRDATA[17]|PRDATA[18]|PRDATA[19]|PRDATA[21]|PRDATA[23]|PRDATA[27]|PRDATA[28]|PRDATA[29]|PRDATA[31]|PRDATA[9]|PSLVERR
+ sky130_fd_sc_hd__fill_1
X$282
+ PRDATA[10]|PRDATA[12]|PRDATA[13]|PRDATA[15]|PRDATA[16]|PRDATA[17]|PRDATA[18]|PRDATA[19]|PRDATA[21]|PRDATA[23]|PRDATA[27]|PRDATA[28]|PRDATA[29]|PRDATA[31]|PRDATA[9]|PSLVERR
+ \$241 \$204 \$70 \$70 sky130_fd_sc_hd__buf_6
X$283 \$70 \$70
+ PRDATA[10]|PRDATA[12]|PRDATA[13]|PRDATA[15]|PRDATA[16]|PRDATA[17]|PRDATA[18]|PRDATA[19]|PRDATA[21]|PRDATA[23]|PRDATA[27]|PRDATA[28]|PRDATA[29]|PRDATA[31]|PRDATA[9]|PSLVERR
+ sky130_fd_sc_hd__fill_8
X$284 \$70 \$70
+ PRDATA[10]|PRDATA[12]|PRDATA[13]|PRDATA[15]|PRDATA[16]|PRDATA[17]|PRDATA[18]|PRDATA[19]|PRDATA[21]|PRDATA[23]|PRDATA[27]|PRDATA[28]|PRDATA[29]|PRDATA[31]|PRDATA[9]|PSLVERR
+ sky130_fd_sc_hd__fill_1
X$285 \$70 \$70
+ PRDATA[10]|PRDATA[12]|PRDATA[13]|PRDATA[15]|PRDATA[16]|PRDATA[17]|PRDATA[18]|PRDATA[19]|PRDATA[21]|PRDATA[23]|PRDATA[27]|PRDATA[28]|PRDATA[29]|PRDATA[31]|PRDATA[9]|PSLVERR
+ sky130_fd_sc_hd__fill_4
X$286 \$70 \$70
+ PRDATA[10]|PRDATA[12]|PRDATA[13]|PRDATA[15]|PRDATA[16]|PRDATA[17]|PRDATA[18]|PRDATA[19]|PRDATA[21]|PRDATA[23]|PRDATA[27]|PRDATA[28]|PRDATA[29]|PRDATA[31]|PRDATA[9]|PSLVERR
+ sky130_fd_sc_hd__fill_2
X$287 \$70
+ PRDATA[10]|PRDATA[12]|PRDATA[13]|PRDATA[15]|PRDATA[16]|PRDATA[17]|PRDATA[18]|PRDATA[19]|PRDATA[21]|PRDATA[23]|PRDATA[27]|PRDATA[28]|PRDATA[29]|PRDATA[31]|PRDATA[9]|PSLVERR
+ sky130_fd_sc_hd__tapvpwrvgnd_1
X$288 \$70 \$70
+ PRDATA[10]|PRDATA[12]|PRDATA[13]|PRDATA[15]|PRDATA[16]|PRDATA[17]|PRDATA[18]|PRDATA[19]|PRDATA[21]|PRDATA[23]|PRDATA[27]|PRDATA[28]|PRDATA[29]|PRDATA[31]|PRDATA[9]|PSLVERR
+ sky130_fd_sc_hd__fill_8
X$289 \$70 \$70
+ PRDATA[10]|PRDATA[12]|PRDATA[13]|PRDATA[15]|PRDATA[16]|PRDATA[17]|PRDATA[18]|PRDATA[19]|PRDATA[21]|PRDATA[23]|PRDATA[27]|PRDATA[28]|PRDATA[29]|PRDATA[31]|PRDATA[9]|PSLVERR
+ sky130_fd_sc_hd__fill_2
X$290 \$70 \$70
+ PRDATA[10]|PRDATA[12]|PRDATA[13]|PRDATA[15]|PRDATA[16]|PRDATA[17]|PRDATA[18]|PRDATA[19]|PRDATA[21]|PRDATA[23]|PRDATA[27]|PRDATA[28]|PRDATA[29]|PRDATA[31]|PRDATA[9]|PSLVERR
+ sky130_fd_sc_hd__fill_1
X$291 \$70
+ PRDATA[10]|PRDATA[12]|PRDATA[13]|PRDATA[15]|PRDATA[16]|PRDATA[17]|PRDATA[18]|PRDATA[19]|PRDATA[21]|PRDATA[23]|PRDATA[27]|PRDATA[28]|PRDATA[29]|PRDATA[31]|PRDATA[9]|PSLVERR
+ PREADY \$70 \$265 sky130_fd_sc_hd__buf_2
X$292 \$70 \$70
+ PRDATA[10]|PRDATA[12]|PRDATA[13]|PRDATA[15]|PRDATA[16]|PRDATA[17]|PRDATA[18]|PRDATA[19]|PRDATA[21]|PRDATA[23]|PRDATA[27]|PRDATA[28]|PRDATA[29]|PRDATA[31]|PRDATA[9]|PSLVERR
+ sky130_fd_sc_hd__fill_8
X$293 \$70 \$70
+ PRDATA[10]|PRDATA[12]|PRDATA[13]|PRDATA[15]|PRDATA[16]|PRDATA[17]|PRDATA[18]|PRDATA[19]|PRDATA[21]|PRDATA[23]|PRDATA[27]|PRDATA[28]|PRDATA[29]|PRDATA[31]|PRDATA[9]|PSLVERR
+ sky130_fd_sc_hd__fill_4
X$294
+ PRDATA[10]|PRDATA[12]|PRDATA[13]|PRDATA[15]|PRDATA[16]|PRDATA[17]|PRDATA[18]|PRDATA[19]|PRDATA[21]|PRDATA[23]|PRDATA[27]|PRDATA[28]|PRDATA[29]|PRDATA[31]|PRDATA[9]|PSLVERR
+ \$148 gpio_out[6] PWDATA[6] \$230 \$70 \$70 sky130_fd_sc_hd__mux2_4
X$295 \$70 \$70
+ PRDATA[10]|PRDATA[12]|PRDATA[13]|PRDATA[15]|PRDATA[16]|PRDATA[17]|PRDATA[18]|PRDATA[19]|PRDATA[21]|PRDATA[23]|PRDATA[27]|PRDATA[28]|PRDATA[29]|PRDATA[31]|PRDATA[9]|PSLVERR
+ sky130_fd_sc_hd__fill_8
X$296 \$70 \$70
+ PRDATA[10]|PRDATA[12]|PRDATA[13]|PRDATA[15]|PRDATA[16]|PRDATA[17]|PRDATA[18]|PRDATA[19]|PRDATA[21]|PRDATA[23]|PRDATA[27]|PRDATA[28]|PRDATA[29]|PRDATA[31]|PRDATA[9]|PSLVERR
+ sky130_fd_sc_hd__fill_8
X$297 \$70 \$70
+ PRDATA[10]|PRDATA[12]|PRDATA[13]|PRDATA[15]|PRDATA[16]|PRDATA[17]|PRDATA[18]|PRDATA[19]|PRDATA[21]|PRDATA[23]|PRDATA[27]|PRDATA[28]|PRDATA[29]|PRDATA[31]|PRDATA[9]|PSLVERR
+ sky130_fd_sc_hd__fill_8
X$298 \$70 \$70
+ PRDATA[10]|PRDATA[12]|PRDATA[13]|PRDATA[15]|PRDATA[16]|PRDATA[17]|PRDATA[18]|PRDATA[19]|PRDATA[21]|PRDATA[23]|PRDATA[27]|PRDATA[28]|PRDATA[29]|PRDATA[31]|PRDATA[9]|PSLVERR
+ sky130_fd_sc_hd__fill_8
X$299 \$70 \$70
+ PRDATA[10]|PRDATA[12]|PRDATA[13]|PRDATA[15]|PRDATA[16]|PRDATA[17]|PRDATA[18]|PRDATA[19]|PRDATA[21]|PRDATA[23]|PRDATA[27]|PRDATA[28]|PRDATA[29]|PRDATA[31]|PRDATA[9]|PSLVERR
+ sky130_fd_sc_hd__fill_8
X$300 \$70 \$70
+ PRDATA[10]|PRDATA[12]|PRDATA[13]|PRDATA[15]|PRDATA[16]|PRDATA[17]|PRDATA[18]|PRDATA[19]|PRDATA[21]|PRDATA[23]|PRDATA[27]|PRDATA[28]|PRDATA[29]|PRDATA[31]|PRDATA[9]|PSLVERR
+ sky130_fd_sc_hd__fill_4
X$301 \$70 VIA_via2_3_1600_480_1_5_320_320
X$302 \$70 VIA_via3_4_1600_480_1_4_400_400
X$303 \$70 VIA_via4_5_1600_480_1_4_400_400
X$304 \$70
+ PRDATA[10]|PRDATA[12]|PRDATA[13]|PRDATA[15]|PRDATA[16]|PRDATA[17]|PRDATA[18]|PRDATA[19]|PRDATA[21]|PRDATA[23]|PRDATA[27]|PRDATA[28]|PRDATA[29]|PRDATA[31]|PRDATA[9]|PSLVERR
+ sky130_fd_sc_hd__tapvpwrvgnd_1
X$305 \$70 \$70
+ PRDATA[10]|PRDATA[12]|PRDATA[13]|PRDATA[15]|PRDATA[16]|PRDATA[17]|PRDATA[18]|PRDATA[19]|PRDATA[21]|PRDATA[23]|PRDATA[27]|PRDATA[28]|PRDATA[29]|PRDATA[31]|PRDATA[9]|PSLVERR
+ sky130_fd_sc_hd__fill_8
X$306 \$70 \$70
+ PRDATA[10]|PRDATA[12]|PRDATA[13]|PRDATA[15]|PRDATA[16]|PRDATA[17]|PRDATA[18]|PRDATA[19]|PRDATA[21]|PRDATA[23]|PRDATA[27]|PRDATA[28]|PRDATA[29]|PRDATA[31]|PRDATA[9]|PSLVERR
+ sky130_fd_sc_hd__fill_2
X$307 \$70 \$70
+ PRDATA[10]|PRDATA[12]|PRDATA[13]|PRDATA[15]|PRDATA[16]|PRDATA[17]|PRDATA[18]|PRDATA[19]|PRDATA[21]|PRDATA[23]|PRDATA[27]|PRDATA[28]|PRDATA[29]|PRDATA[31]|PRDATA[9]|PSLVERR
+ sky130_fd_sc_hd__fill_1
X$308 \$70 \$255
+ PRDATA[10]|PRDATA[12]|PRDATA[13]|PRDATA[15]|PRDATA[16]|PRDATA[17]|PRDATA[18]|PRDATA[19]|PRDATA[21]|PRDATA[23]|PRDATA[27]|PRDATA[28]|PRDATA[29]|PRDATA[31]|PRDATA[9]|PSLVERR
+ \$70 \$101 \$273 sky130_fd_sc_hd__and2b_1
X$309
+ PRDATA[10]|PRDATA[12]|PRDATA[13]|PRDATA[15]|PRDATA[16]|PRDATA[17]|PRDATA[18]|PRDATA[19]|PRDATA[21]|PRDATA[23]|PRDATA[27]|PRDATA[28]|PRDATA[29]|PRDATA[31]|PRDATA[9]|PSLVERR
+ \$255 \$148 \$70 \$70 sky130_fd_sc_hd__buf_6
X$310 \$70 \$70
+ PRDATA[10]|PRDATA[12]|PRDATA[13]|PRDATA[15]|PRDATA[16]|PRDATA[17]|PRDATA[18]|PRDATA[19]|PRDATA[21]|PRDATA[23]|PRDATA[27]|PRDATA[28]|PRDATA[29]|PRDATA[31]|PRDATA[9]|PSLVERR
+ sky130_fd_sc_hd__fill_8
X$311 \$70 \$70
+ PRDATA[10]|PRDATA[12]|PRDATA[13]|PRDATA[15]|PRDATA[16]|PRDATA[17]|PRDATA[18]|PRDATA[19]|PRDATA[21]|PRDATA[23]|PRDATA[27]|PRDATA[28]|PRDATA[29]|PRDATA[31]|PRDATA[9]|PSLVERR
+ sky130_fd_sc_hd__fill_1
X$312 \$70 \$261 PREADY \$70
+ PRDATA[10]|PRDATA[12]|PRDATA[13]|PRDATA[15]|PRDATA[16]|PRDATA[17]|PRDATA[18]|PRDATA[19]|PRDATA[21]|PRDATA[23]|PRDATA[27]|PRDATA[28]|PRDATA[29]|PRDATA[31]|PRDATA[9]|PSLVERR
+ PWRITE sky130_fd_sc_hd__nand2b_1
X$313 \$70 PSEL \$265 \$70 PENABLE
+ PRDATA[10]|PRDATA[12]|PRDATA[13]|PRDATA[15]|PRDATA[16]|PRDATA[17]|PRDATA[18]|PRDATA[19]|PRDATA[21]|PRDATA[23]|PRDATA[27]|PRDATA[28]|PRDATA[29]|PRDATA[31]|PRDATA[9]|PSLVERR
+ sky130_fd_sc_hd__and2_1
X$314 \$70
+ PRDATA[10]|PRDATA[12]|PRDATA[13]|PRDATA[15]|PRDATA[16]|PRDATA[17]|PRDATA[18]|PRDATA[19]|PRDATA[21]|PRDATA[23]|PRDATA[27]|PRDATA[28]|PRDATA[29]|PRDATA[31]|PRDATA[9]|PSLVERR
+ \$72 \$70 \$261 sky130_fd_sc_hd__buf_2
X$315 \$70 \$70
+ PRDATA[10]|PRDATA[12]|PRDATA[13]|PRDATA[15]|PRDATA[16]|PRDATA[17]|PRDATA[18]|PRDATA[19]|PRDATA[21]|PRDATA[23]|PRDATA[27]|PRDATA[28]|PRDATA[29]|PRDATA[31]|PRDATA[9]|PSLVERR
+ sky130_fd_sc_hd__fill_4
X$316 \$70 \$70
+ PRDATA[10]|PRDATA[12]|PRDATA[13]|PRDATA[15]|PRDATA[16]|PRDATA[17]|PRDATA[18]|PRDATA[19]|PRDATA[21]|PRDATA[23]|PRDATA[27]|PRDATA[28]|PRDATA[29]|PRDATA[31]|PRDATA[9]|PSLVERR
+ sky130_fd_sc_hd__fill_2
X$317
+ PRDATA[10]|PRDATA[12]|PRDATA[13]|PRDATA[15]|PRDATA[16]|PRDATA[17]|PRDATA[18]|PRDATA[19]|PRDATA[21]|PRDATA[23]|PRDATA[27]|PRDATA[28]|PRDATA[29]|PRDATA[31]|PRDATA[9]|PSLVERR
+ \$393 \$392 \$70 \$70 sky130_fd_sc_hd__buf_6
X$318 \$70 \$70
+ PRDATA[10]|PRDATA[12]|PRDATA[13]|PRDATA[15]|PRDATA[16]|PRDATA[17]|PRDATA[18]|PRDATA[19]|PRDATA[21]|PRDATA[23]|PRDATA[27]|PRDATA[28]|PRDATA[29]|PRDATA[31]|PRDATA[9]|PSLVERR
+ sky130_fd_sc_hd__fill_8
X$319 \$70 \$70
+ PRDATA[10]|PRDATA[12]|PRDATA[13]|PRDATA[15]|PRDATA[16]|PRDATA[17]|PRDATA[18]|PRDATA[19]|PRDATA[21]|PRDATA[23]|PRDATA[27]|PRDATA[28]|PRDATA[29]|PRDATA[31]|PRDATA[9]|PSLVERR
+ sky130_fd_sc_hd__fill_2
X$320 \$70
+ PRDATA[10]|PRDATA[12]|PRDATA[13]|PRDATA[15]|PRDATA[16]|PRDATA[17]|PRDATA[18]|PRDATA[19]|PRDATA[21]|PRDATA[23]|PRDATA[27]|PRDATA[28]|PRDATA[29]|PRDATA[31]|PRDATA[9]|PSLVERR
+ sky130_fd_sc_hd__tapvpwrvgnd_1
X$321 \$70 \$70
+ PRDATA[10]|PRDATA[12]|PRDATA[13]|PRDATA[15]|PRDATA[16]|PRDATA[17]|PRDATA[18]|PRDATA[19]|PRDATA[21]|PRDATA[23]|PRDATA[27]|PRDATA[28]|PRDATA[29]|PRDATA[31]|PRDATA[9]|PSLVERR
+ sky130_fd_sc_hd__fill_8
X$322 \$70 \$70
+ PRDATA[10]|PRDATA[12]|PRDATA[13]|PRDATA[15]|PRDATA[16]|PRDATA[17]|PRDATA[18]|PRDATA[19]|PRDATA[21]|PRDATA[23]|PRDATA[27]|PRDATA[28]|PRDATA[29]|PRDATA[31]|PRDATA[9]|PSLVERR
+ sky130_fd_sc_hd__fill_8
X$323 \$70 \$70
+ PRDATA[10]|PRDATA[12]|PRDATA[13]|PRDATA[15]|PRDATA[16]|PRDATA[17]|PRDATA[18]|PRDATA[19]|PRDATA[21]|PRDATA[23]|PRDATA[27]|PRDATA[28]|PRDATA[29]|PRDATA[31]|PRDATA[9]|PSLVERR
+ sky130_fd_sc_hd__fill_4
X$324
+ PRDATA[10]|PRDATA[12]|PRDATA[13]|PRDATA[15]|PRDATA[16]|PRDATA[17]|PRDATA[18]|PRDATA[19]|PRDATA[21]|PRDATA[23]|PRDATA[27]|PRDATA[28]|PRDATA[29]|PRDATA[31]|PRDATA[9]|PSLVERR
+ \$446 \$395 \$70 \$70 sky130_fd_sc_hd__buf_6
X$325 \$70 \$70
+ PRDATA[10]|PRDATA[12]|PRDATA[13]|PRDATA[15]|PRDATA[16]|PRDATA[17]|PRDATA[18]|PRDATA[19]|PRDATA[21]|PRDATA[23]|PRDATA[27]|PRDATA[28]|PRDATA[29]|PRDATA[31]|PRDATA[9]|PSLVERR
+ sky130_fd_sc_hd__fill_8
X$326 \$70 \$70
+ PRDATA[10]|PRDATA[12]|PRDATA[13]|PRDATA[15]|PRDATA[16]|PRDATA[17]|PRDATA[18]|PRDATA[19]|PRDATA[21]|PRDATA[23]|PRDATA[27]|PRDATA[28]|PRDATA[29]|PRDATA[31]|PRDATA[9]|PSLVERR
+ sky130_fd_sc_hd__fill_8
X$327 \$70 \$70
+ PRDATA[10]|PRDATA[12]|PRDATA[13]|PRDATA[15]|PRDATA[16]|PRDATA[17]|PRDATA[18]|PRDATA[19]|PRDATA[21]|PRDATA[23]|PRDATA[27]|PRDATA[28]|PRDATA[29]|PRDATA[31]|PRDATA[9]|PSLVERR
+ sky130_fd_sc_hd__fill_8
X$328 \$70 \$70
+ PRDATA[10]|PRDATA[12]|PRDATA[13]|PRDATA[15]|PRDATA[16]|PRDATA[17]|PRDATA[18]|PRDATA[19]|PRDATA[21]|PRDATA[23]|PRDATA[27]|PRDATA[28]|PRDATA[29]|PRDATA[31]|PRDATA[9]|PSLVERR
+ sky130_fd_sc_hd__fill_4
X$329 \$70 \$70
+ PRDATA[10]|PRDATA[12]|PRDATA[13]|PRDATA[15]|PRDATA[16]|PRDATA[17]|PRDATA[18]|PRDATA[19]|PRDATA[21]|PRDATA[23]|PRDATA[27]|PRDATA[28]|PRDATA[29]|PRDATA[31]|PRDATA[9]|PSLVERR
+ sky130_fd_sc_hd__fill_2
X$330 \$70
+ PRDATA[10]|PRDATA[12]|PRDATA[13]|PRDATA[15]|PRDATA[16]|PRDATA[17]|PRDATA[18]|PRDATA[19]|PRDATA[21]|PRDATA[23]|PRDATA[27]|PRDATA[28]|PRDATA[29]|PRDATA[31]|PRDATA[9]|PSLVERR
+ sky130_fd_sc_hd__tapvpwrvgnd_1
X$331 \$70 \$70
+ PRDATA[10]|PRDATA[12]|PRDATA[13]|PRDATA[15]|PRDATA[16]|PRDATA[17]|PRDATA[18]|PRDATA[19]|PRDATA[21]|PRDATA[23]|PRDATA[27]|PRDATA[28]|PRDATA[29]|PRDATA[31]|PRDATA[9]|PSLVERR
+ sky130_fd_sc_hd__fill_4
X$332 \$70 \$70
+ PRDATA[10]|PRDATA[12]|PRDATA[13]|PRDATA[15]|PRDATA[16]|PRDATA[17]|PRDATA[18]|PRDATA[19]|PRDATA[21]|PRDATA[23]|PRDATA[27]|PRDATA[28]|PRDATA[29]|PRDATA[31]|PRDATA[9]|PSLVERR
+ sky130_fd_sc_hd__fill_1
X$333 \$70
+ PRDATA[10]|PRDATA[12]|PRDATA[13]|PRDATA[15]|PRDATA[16]|PRDATA[17]|PRDATA[18]|PRDATA[19]|PRDATA[21]|PRDATA[23]|PRDATA[27]|PRDATA[28]|PRDATA[29]|PRDATA[31]|PRDATA[9]|PSLVERR
+ \$330 PRDATA[24] \$313 \$70 sky130_fd_sc_hd__nor2_2
X$334 \$70
+ PRDATA[10]|PRDATA[12]|PRDATA[13]|PRDATA[15]|PRDATA[16]|PRDATA[17]|PRDATA[18]|PRDATA[19]|PRDATA[21]|PRDATA[23]|PRDATA[27]|PRDATA[28]|PRDATA[29]|PRDATA[31]|PRDATA[9]|PSLVERR
+ \$330 PRDATA[25] \$313 \$70 sky130_fd_sc_hd__nor2_2
X$335 \$70
+ PRDATA[10]|PRDATA[12]|PRDATA[13]|PRDATA[15]|PRDATA[16]|PRDATA[17]|PRDATA[18]|PRDATA[19]|PRDATA[21]|PRDATA[23]|PRDATA[27]|PRDATA[28]|PRDATA[29]|PRDATA[31]|PRDATA[9]|PSLVERR
+ \$330 PRDATA[14] \$313 \$70 sky130_fd_sc_hd__nor2_2
X$336 \$70 \$70
+ PRDATA[10]|PRDATA[12]|PRDATA[13]|PRDATA[15]|PRDATA[16]|PRDATA[17]|PRDATA[18]|PRDATA[19]|PRDATA[21]|PRDATA[23]|PRDATA[27]|PRDATA[28]|PRDATA[29]|PRDATA[31]|PRDATA[9]|PSLVERR
+ sky130_fd_sc_hd__fill_2
X$337 \$70 \$70
+ PRDATA[10]|PRDATA[12]|PRDATA[13]|PRDATA[15]|PRDATA[16]|PRDATA[17]|PRDATA[18]|PRDATA[19]|PRDATA[21]|PRDATA[23]|PRDATA[27]|PRDATA[28]|PRDATA[29]|PRDATA[31]|PRDATA[9]|PSLVERR
+ sky130_fd_sc_hd__fill_1
X$338 \$70 \$70
+ PRDATA[10]|PRDATA[12]|PRDATA[13]|PRDATA[15]|PRDATA[16]|PRDATA[17]|PRDATA[18]|PRDATA[19]|PRDATA[21]|PRDATA[23]|PRDATA[27]|PRDATA[28]|PRDATA[29]|PRDATA[31]|PRDATA[9]|PSLVERR
+ sky130_fd_sc_hd__fill_8
X$339 \$70 \$70
+ PRDATA[10]|PRDATA[12]|PRDATA[13]|PRDATA[15]|PRDATA[16]|PRDATA[17]|PRDATA[18]|PRDATA[19]|PRDATA[21]|PRDATA[23]|PRDATA[27]|PRDATA[28]|PRDATA[29]|PRDATA[31]|PRDATA[9]|PSLVERR
+ sky130_fd_sc_hd__fill_8
X$340 \$70 \$70
+ PRDATA[10]|PRDATA[12]|PRDATA[13]|PRDATA[15]|PRDATA[16]|PRDATA[17]|PRDATA[18]|PRDATA[19]|PRDATA[21]|PRDATA[23]|PRDATA[27]|PRDATA[28]|PRDATA[29]|PRDATA[31]|PRDATA[9]|PSLVERR
+ sky130_fd_sc_hd__fill_8
X$341 \$70 \$70
+ PRDATA[10]|PRDATA[12]|PRDATA[13]|PRDATA[15]|PRDATA[16]|PRDATA[17]|PRDATA[18]|PRDATA[19]|PRDATA[21]|PRDATA[23]|PRDATA[27]|PRDATA[28]|PRDATA[29]|PRDATA[31]|PRDATA[9]|PSLVERR
+ sky130_fd_sc_hd__fill_8
X$342 \$70 \$70
+ PRDATA[10]|PRDATA[12]|PRDATA[13]|PRDATA[15]|PRDATA[16]|PRDATA[17]|PRDATA[18]|PRDATA[19]|PRDATA[21]|PRDATA[23]|PRDATA[27]|PRDATA[28]|PRDATA[29]|PRDATA[31]|PRDATA[9]|PSLVERR
+ sky130_fd_sc_hd__fill_4
X$343 \$70 \$70
+ PRDATA[10]|PRDATA[12]|PRDATA[13]|PRDATA[15]|PRDATA[16]|PRDATA[17]|PRDATA[18]|PRDATA[19]|PRDATA[21]|PRDATA[23]|PRDATA[27]|PRDATA[28]|PRDATA[29]|PRDATA[31]|PRDATA[9]|PSLVERR
+ sky130_fd_sc_hd__fill_1
X$344
+ PRDATA[10]|PRDATA[12]|PRDATA[13]|PRDATA[15]|PRDATA[16]|PRDATA[17]|PRDATA[18]|PRDATA[19]|PRDATA[21]|PRDATA[23]|PRDATA[27]|PRDATA[28]|PRDATA[29]|PRDATA[31]|PRDATA[9]|PSLVERR
+ \$223 \$346 \$70 \$70 sky130_fd_sc_hd__clkbuf_16
X$345 \$70 \$70
+ PRDATA[10]|PRDATA[12]|PRDATA[13]|PRDATA[15]|PRDATA[16]|PRDATA[17]|PRDATA[18]|PRDATA[19]|PRDATA[21]|PRDATA[23]|PRDATA[27]|PRDATA[28]|PRDATA[29]|PRDATA[31]|PRDATA[9]|PSLVERR
+ sky130_fd_sc_hd__fill_2
X$346 \$70 VIA_via2_3_1600_480_1_5_320_320
X$347 \$70 \$70
+ PRDATA[10]|PRDATA[12]|PRDATA[13]|PRDATA[15]|PRDATA[16]|PRDATA[17]|PRDATA[18]|PRDATA[19]|PRDATA[21]|PRDATA[23]|PRDATA[27]|PRDATA[28]|PRDATA[29]|PRDATA[31]|PRDATA[9]|PSLVERR
+ sky130_fd_sc_hd__fill_1
X$348 \$70
+ PRDATA[10]|PRDATA[12]|PRDATA[13]|PRDATA[15]|PRDATA[16]|PRDATA[17]|PRDATA[18]|PRDATA[19]|PRDATA[21]|PRDATA[23]|PRDATA[27]|PRDATA[28]|PRDATA[29]|PRDATA[31]|PRDATA[9]|PSLVERR
+ sky130_fd_sc_hd__tapvpwrvgnd_1
X$349 \$70 \$70
+ PRDATA[10]|PRDATA[12]|PRDATA[13]|PRDATA[15]|PRDATA[16]|PRDATA[17]|PRDATA[18]|PRDATA[19]|PRDATA[21]|PRDATA[23]|PRDATA[27]|PRDATA[28]|PRDATA[29]|PRDATA[31]|PRDATA[9]|PSLVERR
+ sky130_fd_sc_hd__fill_8
X$350 \$70 \$70
+ PRDATA[10]|PRDATA[12]|PRDATA[13]|PRDATA[15]|PRDATA[16]|PRDATA[17]|PRDATA[18]|PRDATA[19]|PRDATA[21]|PRDATA[23]|PRDATA[27]|PRDATA[28]|PRDATA[29]|PRDATA[31]|PRDATA[9]|PSLVERR
+ sky130_fd_sc_hd__fill_4
X$351 \$70 \$435 \$70
+ PRDATA[10]|PRDATA[12]|PRDATA[13]|PRDATA[15]|PRDATA[16]|PRDATA[17]|PRDATA[18]|PRDATA[19]|PRDATA[21]|PRDATA[23]|PRDATA[27]|PRDATA[28]|PRDATA[29]|PRDATA[31]|PRDATA[9]|PSLVERR
+ \$418 sky130_fd_sc_hd__buf_4
X$352 \$70 \$70
+ PRDATA[10]|PRDATA[12]|PRDATA[13]|PRDATA[15]|PRDATA[16]|PRDATA[17]|PRDATA[18]|PRDATA[19]|PRDATA[21]|PRDATA[23]|PRDATA[27]|PRDATA[28]|PRDATA[29]|PRDATA[31]|PRDATA[9]|PSLVERR
+ sky130_fd_sc_hd__fill_2
X$353 \$70 \$406 \$70
+ PRDATA[10]|PRDATA[12]|PRDATA[13]|PRDATA[15]|PRDATA[16]|PRDATA[17]|PRDATA[18]|PRDATA[19]|PRDATA[21]|PRDATA[23]|PRDATA[27]|PRDATA[28]|PRDATA[29]|PRDATA[31]|PRDATA[9]|PSLVERR
+ gpio_oe[4] \$126 sky130_fd_sc_hd__nand2_1
X$354 \$70 \$70 \$406 PRDATA[4] \$399
+ PRDATA[10]|PRDATA[12]|PRDATA[13]|PRDATA[15]|PRDATA[16]|PRDATA[17]|PRDATA[18]|PRDATA[19]|PRDATA[21]|PRDATA[23]|PRDATA[27]|PRDATA[28]|PRDATA[29]|PRDATA[31]|PRDATA[9]|PSLVERR
+ \$72 sky130_fd_sc_hd__a21oi_2
X$355 \$70 \$70
+ PRDATA[10]|PRDATA[12]|PRDATA[13]|PRDATA[15]|PRDATA[16]|PRDATA[17]|PRDATA[18]|PRDATA[19]|PRDATA[21]|PRDATA[23]|PRDATA[27]|PRDATA[28]|PRDATA[29]|PRDATA[31]|PRDATA[9]|PSLVERR
+ sky130_fd_sc_hd__fill_8
X$356 \$70 \$70
+ PRDATA[10]|PRDATA[12]|PRDATA[13]|PRDATA[15]|PRDATA[16]|PRDATA[17]|PRDATA[18]|PRDATA[19]|PRDATA[21]|PRDATA[23]|PRDATA[27]|PRDATA[28]|PRDATA[29]|PRDATA[31]|PRDATA[9]|PSLVERR
+ sky130_fd_sc_hd__fill_2
X$357 \$70
+ PRDATA[10]|PRDATA[12]|PRDATA[13]|PRDATA[15]|PRDATA[16]|PRDATA[17]|PRDATA[18]|PRDATA[19]|PRDATA[21]|PRDATA[23]|PRDATA[27]|PRDATA[28]|PRDATA[29]|PRDATA[31]|PRDATA[9]|PSLVERR
+ \$330 PRDATA[11] \$313 \$70 sky130_fd_sc_hd__nor2_2
X$358 \$70 \$70
+ PRDATA[10]|PRDATA[12]|PRDATA[13]|PRDATA[15]|PRDATA[16]|PRDATA[17]|PRDATA[18]|PRDATA[19]|PRDATA[21]|PRDATA[23]|PRDATA[27]|PRDATA[28]|PRDATA[29]|PRDATA[31]|PRDATA[9]|PSLVERR
+ sky130_fd_sc_hd__fill_8
X$359 \$70 VIA_via3_4_1600_480_1_4_400_400
X$360 \$70 VIA_via4_5_1600_480_1_4_400_400
X$361 \$70 \$70
+ PRDATA[10]|PRDATA[12]|PRDATA[13]|PRDATA[15]|PRDATA[16]|PRDATA[17]|PRDATA[18]|PRDATA[19]|PRDATA[21]|PRDATA[23]|PRDATA[27]|PRDATA[28]|PRDATA[29]|PRDATA[31]|PRDATA[9]|PSLVERR
+ sky130_fd_sc_hd__fill_1
X$362 \$70 \$70
+ PRDATA[10]|PRDATA[12]|PRDATA[13]|PRDATA[15]|PRDATA[16]|PRDATA[17]|PRDATA[18]|PRDATA[19]|PRDATA[21]|PRDATA[23]|PRDATA[27]|PRDATA[28]|PRDATA[29]|PRDATA[31]|PRDATA[9]|PSLVERR
+ sky130_fd_sc_hd__fill_4
X$363 \$70 \$70
+ PRDATA[10]|PRDATA[12]|PRDATA[13]|PRDATA[15]|PRDATA[16]|PRDATA[17]|PRDATA[18]|PRDATA[19]|PRDATA[21]|PRDATA[23]|PRDATA[27]|PRDATA[28]|PRDATA[29]|PRDATA[31]|PRDATA[9]|PSLVERR
+ sky130_fd_sc_hd__fill_2
X$364 \$70 \$70
+ PRDATA[10]|PRDATA[12]|PRDATA[13]|PRDATA[15]|PRDATA[16]|PRDATA[17]|PRDATA[18]|PRDATA[19]|PRDATA[21]|PRDATA[23]|PRDATA[27]|PRDATA[28]|PRDATA[29]|PRDATA[31]|PRDATA[9]|PSLVERR
+ sky130_fd_sc_hd__fill_1
X$365
+ PRDATA[10]|PRDATA[12]|PRDATA[13]|PRDATA[15]|PRDATA[16]|PRDATA[17]|PRDATA[18]|PRDATA[19]|PRDATA[21]|PRDATA[23]|PRDATA[27]|PRDATA[28]|PRDATA[29]|PRDATA[31]|PRDATA[9]|PSLVERR
+ \$147 \$179 \$70 \$70 sky130_fd_sc_hd__buf_6
X$366 \$70 \$70
+ PRDATA[10]|PRDATA[12]|PRDATA[13]|PRDATA[15]|PRDATA[16]|PRDATA[17]|PRDATA[18]|PRDATA[19]|PRDATA[21]|PRDATA[23]|PRDATA[27]|PRDATA[28]|PRDATA[29]|PRDATA[31]|PRDATA[9]|PSLVERR
+ sky130_fd_sc_hd__fill_4
X$367 \$70
+ PRDATA[10]|PRDATA[12]|PRDATA[13]|PRDATA[15]|PRDATA[16]|PRDATA[17]|PRDATA[18]|PRDATA[19]|PRDATA[21]|PRDATA[23]|PRDATA[27]|PRDATA[28]|PRDATA[29]|PRDATA[31]|PRDATA[9]|PSLVERR
+ sky130_fd_sc_hd__tapvpwrvgnd_1
X$368 \$70 \$70
+ PRDATA[10]|PRDATA[12]|PRDATA[13]|PRDATA[15]|PRDATA[16]|PRDATA[17]|PRDATA[18]|PRDATA[19]|PRDATA[21]|PRDATA[23]|PRDATA[27]|PRDATA[28]|PRDATA[29]|PRDATA[31]|PRDATA[9]|PSLVERR
+ sky130_fd_sc_hd__fill_8
X$369 \$70 \$70
+ PRDATA[10]|PRDATA[12]|PRDATA[13]|PRDATA[15]|PRDATA[16]|PRDATA[17]|PRDATA[18]|PRDATA[19]|PRDATA[21]|PRDATA[23]|PRDATA[27]|PRDATA[28]|PRDATA[29]|PRDATA[31]|PRDATA[9]|PSLVERR
+ sky130_fd_sc_hd__fill_4
X$370 \$70 \$70
+ PRDATA[10]|PRDATA[12]|PRDATA[13]|PRDATA[15]|PRDATA[16]|PRDATA[17]|PRDATA[18]|PRDATA[19]|PRDATA[21]|PRDATA[23]|PRDATA[27]|PRDATA[28]|PRDATA[29]|PRDATA[31]|PRDATA[9]|PSLVERR
+ sky130_fd_sc_hd__fill_1
X$371 \$70 \$142 \$70
+ PRDATA[10]|PRDATA[12]|PRDATA[13]|PRDATA[15]|PRDATA[16]|PRDATA[17]|PRDATA[18]|PRDATA[19]|PRDATA[21]|PRDATA[23]|PRDATA[27]|PRDATA[28]|PRDATA[29]|PRDATA[31]|PRDATA[9]|PSLVERR
+ \$182 sky130_fd_sc_hd__buf_4
X$372 \$70 \$70
+ PRDATA[10]|PRDATA[12]|PRDATA[13]|PRDATA[15]|PRDATA[16]|PRDATA[17]|PRDATA[18]|PRDATA[19]|PRDATA[21]|PRDATA[23]|PRDATA[27]|PRDATA[28]|PRDATA[29]|PRDATA[31]|PRDATA[9]|PSLVERR
+ sky130_fd_sc_hd__fill_2
X$373 \$70 \$70
+ PRDATA[10]|PRDATA[12]|PRDATA[13]|PRDATA[15]|PRDATA[16]|PRDATA[17]|PRDATA[18]|PRDATA[19]|PRDATA[21]|PRDATA[23]|PRDATA[27]|PRDATA[28]|PRDATA[29]|PRDATA[31]|PRDATA[9]|PSLVERR
+ sky130_fd_sc_hd__fill_2
X$374 \$70 \$70
+ PRDATA[10]|PRDATA[12]|PRDATA[13]|PRDATA[15]|PRDATA[16]|PRDATA[17]|PRDATA[18]|PRDATA[19]|PRDATA[21]|PRDATA[23]|PRDATA[27]|PRDATA[28]|PRDATA[29]|PRDATA[31]|PRDATA[9]|PSLVERR
+ sky130_fd_sc_hd__fill_1
X$375 \$70 \$70
+ PRDATA[10]|PRDATA[12]|PRDATA[13]|PRDATA[15]|PRDATA[16]|PRDATA[17]|PRDATA[18]|PRDATA[19]|PRDATA[21]|PRDATA[23]|PRDATA[27]|PRDATA[28]|PRDATA[29]|PRDATA[31]|PRDATA[9]|PSLVERR
+ sky130_fd_sc_hd__fill_4
X$376 \$70 \$70
+ PRDATA[10]|PRDATA[12]|PRDATA[13]|PRDATA[15]|PRDATA[16]|PRDATA[17]|PRDATA[18]|PRDATA[19]|PRDATA[21]|PRDATA[23]|PRDATA[27]|PRDATA[28]|PRDATA[29]|PRDATA[31]|PRDATA[9]|PSLVERR
+ sky130_fd_sc_hd__fill_2
X$377 \$70
+ PRDATA[10]|PRDATA[12]|PRDATA[13]|PRDATA[15]|PRDATA[16]|PRDATA[17]|PRDATA[18]|PRDATA[19]|PRDATA[21]|PRDATA[23]|PRDATA[27]|PRDATA[28]|PRDATA[29]|PRDATA[31]|PRDATA[9]|PSLVERR
+ sky130_fd_sc_hd__tapvpwrvgnd_1
X$378 \$70 \$70
+ PRDATA[10]|PRDATA[12]|PRDATA[13]|PRDATA[15]|PRDATA[16]|PRDATA[17]|PRDATA[18]|PRDATA[19]|PRDATA[21]|PRDATA[23]|PRDATA[27]|PRDATA[28]|PRDATA[29]|PRDATA[31]|PRDATA[9]|PSLVERR
+ sky130_fd_sc_hd__fill_8
X$379 \$70 \$70
+ PRDATA[10]|PRDATA[12]|PRDATA[13]|PRDATA[15]|PRDATA[16]|PRDATA[17]|PRDATA[18]|PRDATA[19]|PRDATA[21]|PRDATA[23]|PRDATA[27]|PRDATA[28]|PRDATA[29]|PRDATA[31]|PRDATA[9]|PSLVERR
+ sky130_fd_sc_hd__fill_8
X$380 \$70 \$70
+ PRDATA[10]|PRDATA[12]|PRDATA[13]|PRDATA[15]|PRDATA[16]|PRDATA[17]|PRDATA[18]|PRDATA[19]|PRDATA[21]|PRDATA[23]|PRDATA[27]|PRDATA[28]|PRDATA[29]|PRDATA[31]|PRDATA[9]|PSLVERR
+ sky130_fd_sc_hd__fill_4
X$381 \$70 \$70
+ PRDATA[10]|PRDATA[12]|PRDATA[13]|PRDATA[15]|PRDATA[16]|PRDATA[17]|PRDATA[18]|PRDATA[19]|PRDATA[21]|PRDATA[23]|PRDATA[27]|PRDATA[28]|PRDATA[29]|PRDATA[31]|PRDATA[9]|PSLVERR
+ sky130_fd_sc_hd__fill_2
X$382 \$70 \$70
+ PRDATA[10]|PRDATA[12]|PRDATA[13]|PRDATA[15]|PRDATA[16]|PRDATA[17]|PRDATA[18]|PRDATA[19]|PRDATA[21]|PRDATA[23]|PRDATA[27]|PRDATA[28]|PRDATA[29]|PRDATA[31]|PRDATA[9]|PSLVERR
+ sky130_fd_sc_hd__fill_1
X$383 \$70 \$70
+ PRDATA[10]|PRDATA[12]|PRDATA[13]|PRDATA[15]|PRDATA[16]|PRDATA[17]|PRDATA[18]|PRDATA[19]|PRDATA[21]|PRDATA[23]|PRDATA[27]|PRDATA[28]|PRDATA[29]|PRDATA[31]|PRDATA[9]|PSLVERR
+ sky130_fd_sc_hd__fill_4
X$384 \$70 \$70
+ PRDATA[10]|PRDATA[12]|PRDATA[13]|PRDATA[15]|PRDATA[16]|PRDATA[17]|PRDATA[18]|PRDATA[19]|PRDATA[21]|PRDATA[23]|PRDATA[27]|PRDATA[28]|PRDATA[29]|PRDATA[31]|PRDATA[9]|PSLVERR
+ sky130_fd_sc_hd__fill_2
X$385 \$70 \$70
+ PRDATA[10]|PRDATA[12]|PRDATA[13]|PRDATA[15]|PRDATA[16]|PRDATA[17]|PRDATA[18]|PRDATA[19]|PRDATA[21]|PRDATA[23]|PRDATA[27]|PRDATA[28]|PRDATA[29]|PRDATA[31]|PRDATA[9]|PSLVERR
+ sky130_fd_sc_hd__fill_1
X$386 \$70 \$70
+ PRDATA[10]|PRDATA[12]|PRDATA[13]|PRDATA[15]|PRDATA[16]|PRDATA[17]|PRDATA[18]|PRDATA[19]|PRDATA[21]|PRDATA[23]|PRDATA[27]|PRDATA[28]|PRDATA[29]|PRDATA[31]|PRDATA[9]|PSLVERR
+ sky130_fd_sc_hd__fill_8
X$387
+ PRDATA[10]|PRDATA[12]|PRDATA[13]|PRDATA[15]|PRDATA[16]|PRDATA[17]|PRDATA[18]|PRDATA[19]|PRDATA[21]|PRDATA[23]|PRDATA[27]|PRDATA[28]|PRDATA[29]|PRDATA[31]|PRDATA[9]|PSLVERR
+ \$223 \$78 \$70 \$70 sky130_fd_sc_hd__clkbuf_16
X$388 \$70 \$70
+ PRDATA[10]|PRDATA[12]|PRDATA[13]|PRDATA[15]|PRDATA[16]|PRDATA[17]|PRDATA[18]|PRDATA[19]|PRDATA[21]|PRDATA[23]|PRDATA[27]|PRDATA[28]|PRDATA[29]|PRDATA[31]|PRDATA[9]|PSLVERR
+ sky130_fd_sc_hd__fill_4
X$389 \$70 VIA_via2_3_1600_480_1_5_320_320
X$390 \$70 \$70
+ PRDATA[10]|PRDATA[12]|PRDATA[13]|PRDATA[15]|PRDATA[16]|PRDATA[17]|PRDATA[18]|PRDATA[19]|PRDATA[21]|PRDATA[23]|PRDATA[27]|PRDATA[28]|PRDATA[29]|PRDATA[31]|PRDATA[9]|PSLVERR
+ sky130_fd_sc_hd__fill_1
X$391 \$70
+ PRDATA[10]|PRDATA[12]|PRDATA[13]|PRDATA[15]|PRDATA[16]|PRDATA[17]|PRDATA[18]|PRDATA[19]|PRDATA[21]|PRDATA[23]|PRDATA[27]|PRDATA[28]|PRDATA[29]|PRDATA[31]|PRDATA[9]|PSLVERR
+ sky130_fd_sc_hd__tapvpwrvgnd_1
X$392 \$70 \$70
+ PRDATA[10]|PRDATA[12]|PRDATA[13]|PRDATA[15]|PRDATA[16]|PRDATA[17]|PRDATA[18]|PRDATA[19]|PRDATA[21]|PRDATA[23]|PRDATA[27]|PRDATA[28]|PRDATA[29]|PRDATA[31]|PRDATA[9]|PSLVERR
+ sky130_fd_sc_hd__fill_8
X$393 \$70 \$70
+ PRDATA[10]|PRDATA[12]|PRDATA[13]|PRDATA[15]|PRDATA[16]|PRDATA[17]|PRDATA[18]|PRDATA[19]|PRDATA[21]|PRDATA[23]|PRDATA[27]|PRDATA[28]|PRDATA[29]|PRDATA[31]|PRDATA[9]|PSLVERR
+ sky130_fd_sc_hd__fill_8
X$394 \$70 \$70
+ PRDATA[10]|PRDATA[12]|PRDATA[13]|PRDATA[15]|PRDATA[16]|PRDATA[17]|PRDATA[18]|PRDATA[19]|PRDATA[21]|PRDATA[23]|PRDATA[27]|PRDATA[28]|PRDATA[29]|PRDATA[31]|PRDATA[9]|PSLVERR
+ sky130_fd_sc_hd__fill_8
X$395 \$70 \$70
+ PRDATA[10]|PRDATA[12]|PRDATA[13]|PRDATA[15]|PRDATA[16]|PRDATA[17]|PRDATA[18]|PRDATA[19]|PRDATA[21]|PRDATA[23]|PRDATA[27]|PRDATA[28]|PRDATA[29]|PRDATA[31]|PRDATA[9]|PSLVERR
+ sky130_fd_sc_hd__fill_2
X$396 \$70 \$70 \$213 PRDATA[3] \$151
+ PRDATA[10]|PRDATA[12]|PRDATA[13]|PRDATA[15]|PRDATA[16]|PRDATA[17]|PRDATA[18]|PRDATA[19]|PRDATA[21]|PRDATA[23]|PRDATA[27]|PRDATA[28]|PRDATA[29]|PRDATA[31]|PRDATA[9]|PSLVERR
+ \$72 sky130_fd_sc_hd__a21oi_2
X$397 \$70 \$70
+ PRDATA[10]|PRDATA[12]|PRDATA[13]|PRDATA[15]|PRDATA[16]|PRDATA[17]|PRDATA[18]|PRDATA[19]|PRDATA[21]|PRDATA[23]|PRDATA[27]|PRDATA[28]|PRDATA[29]|PRDATA[31]|PRDATA[9]|PSLVERR
+ sky130_fd_sc_hd__fill_8
X$398 \$70 \$70
+ PRDATA[10]|PRDATA[12]|PRDATA[13]|PRDATA[15]|PRDATA[16]|PRDATA[17]|PRDATA[18]|PRDATA[19]|PRDATA[21]|PRDATA[23]|PRDATA[27]|PRDATA[28]|PRDATA[29]|PRDATA[31]|PRDATA[9]|PSLVERR
+ sky130_fd_sc_hd__fill_8
X$399 \$70 VIA_via3_4_1600_480_1_4_400_400
X$400 \$70 VIA_via4_5_1600_480_1_4_400_400
X$401 \$70 \$70
+ PRDATA[10]|PRDATA[12]|PRDATA[13]|PRDATA[15]|PRDATA[16]|PRDATA[17]|PRDATA[18]|PRDATA[19]|PRDATA[21]|PRDATA[23]|PRDATA[27]|PRDATA[28]|PRDATA[29]|PRDATA[31]|PRDATA[9]|PSLVERR
+ sky130_fd_sc_hd__fill_2
X$402 \$70 \$70
+ PRDATA[10]|PRDATA[12]|PRDATA[13]|PRDATA[15]|PRDATA[16]|PRDATA[17]|PRDATA[18]|PRDATA[19]|PRDATA[21]|PRDATA[23]|PRDATA[27]|PRDATA[28]|PRDATA[29]|PRDATA[31]|PRDATA[9]|PSLVERR
+ sky130_fd_sc_hd__fill_4
X$403 \$70 \$70
+ PRDATA[10]|PRDATA[12]|PRDATA[13]|PRDATA[15]|PRDATA[16]|PRDATA[17]|PRDATA[18]|PRDATA[19]|PRDATA[21]|PRDATA[23]|PRDATA[27]|PRDATA[28]|PRDATA[29]|PRDATA[31]|PRDATA[9]|PSLVERR
+ sky130_fd_sc_hd__fill_1
X$404 \$70 \$70
+ PRDATA[10]|PRDATA[12]|PRDATA[13]|PRDATA[15]|PRDATA[16]|PRDATA[17]|PRDATA[18]|PRDATA[19]|PRDATA[21]|PRDATA[23]|PRDATA[27]|PRDATA[28]|PRDATA[29]|PRDATA[31]|PRDATA[9]|PSLVERR
+ sky130_fd_sc_hd__conb_1
X$405 \$70
+ PRDATA[10]|PRDATA[12]|PRDATA[13]|PRDATA[15]|PRDATA[16]|PRDATA[17]|PRDATA[18]|PRDATA[19]|PRDATA[21]|PRDATA[23]|PRDATA[27]|PRDATA[28]|PRDATA[29]|PRDATA[31]|PRDATA[9]|PSLVERR
+ sky130_fd_sc_hd__tapvpwrvgnd_1
X$406 \$70 \$70
+ PRDATA[10]|PRDATA[12]|PRDATA[13]|PRDATA[15]|PRDATA[16]|PRDATA[17]|PRDATA[18]|PRDATA[19]|PRDATA[21]|PRDATA[23]|PRDATA[27]|PRDATA[28]|PRDATA[29]|PRDATA[31]|PRDATA[9]|PSLVERR
+ sky130_fd_sc_hd__fill_2
X$407 \$70 \$70
+ PRDATA[10]|PRDATA[12]|PRDATA[13]|PRDATA[15]|PRDATA[16]|PRDATA[17]|PRDATA[18]|PRDATA[19]|PRDATA[21]|PRDATA[23]|PRDATA[27]|PRDATA[28]|PRDATA[29]|PRDATA[31]|PRDATA[9]|PSLVERR
+ sky130_fd_sc_hd__fill_4
X$408 \$70 \$70
+ PRDATA[10]|PRDATA[12]|PRDATA[13]|PRDATA[15]|PRDATA[16]|PRDATA[17]|PRDATA[18]|PRDATA[19]|PRDATA[21]|PRDATA[23]|PRDATA[27]|PRDATA[28]|PRDATA[29]|PRDATA[31]|PRDATA[9]|PSLVERR
+ sky130_fd_sc_hd__fill_2
X$409 \$70 \$70
+ PRDATA[10]|PRDATA[12]|PRDATA[13]|PRDATA[15]|PRDATA[16]|PRDATA[17]|PRDATA[18]|PRDATA[19]|PRDATA[21]|PRDATA[23]|PRDATA[27]|PRDATA[28]|PRDATA[29]|PRDATA[31]|PRDATA[9]|PSLVERR
+ sky130_fd_sc_hd__fill_4
X$410 \$70 \$70
+ PRDATA[10]|PRDATA[12]|PRDATA[13]|PRDATA[15]|PRDATA[16]|PRDATA[17]|PRDATA[18]|PRDATA[19]|PRDATA[21]|PRDATA[23]|PRDATA[27]|PRDATA[28]|PRDATA[29]|PRDATA[31]|PRDATA[9]|PSLVERR
+ sky130_fd_sc_hd__fill_2
X$411 \$70
+ PRDATA[10]|PRDATA[12]|PRDATA[13]|PRDATA[15]|PRDATA[16]|PRDATA[17]|PRDATA[18]|PRDATA[19]|PRDATA[21]|PRDATA[23]|PRDATA[27]|PRDATA[28]|PRDATA[29]|PRDATA[31]|PRDATA[9]|PSLVERR
+ sky130_fd_sc_hd__tapvpwrvgnd_1
X$412 \$70 \$70
+ PRDATA[10]|PRDATA[12]|PRDATA[13]|PRDATA[15]|PRDATA[16]|PRDATA[17]|PRDATA[18]|PRDATA[19]|PRDATA[21]|PRDATA[23]|PRDATA[27]|PRDATA[28]|PRDATA[29]|PRDATA[31]|PRDATA[9]|PSLVERR
+ sky130_fd_sc_hd__fill_8
X$413 \$70 \$70
+ PRDATA[10]|PRDATA[12]|PRDATA[13]|PRDATA[15]|PRDATA[16]|PRDATA[17]|PRDATA[18]|PRDATA[19]|PRDATA[21]|PRDATA[23]|PRDATA[27]|PRDATA[28]|PRDATA[29]|PRDATA[31]|PRDATA[9]|PSLVERR
+ sky130_fd_sc_hd__fill_8
X$414 \$70 \$70
+ PRDATA[10]|PRDATA[12]|PRDATA[13]|PRDATA[15]|PRDATA[16]|PRDATA[17]|PRDATA[18]|PRDATA[19]|PRDATA[21]|PRDATA[23]|PRDATA[27]|PRDATA[28]|PRDATA[29]|PRDATA[31]|PRDATA[9]|PSLVERR
+ sky130_fd_sc_hd__fill_4
X$415 \$70 \$70
+ PRDATA[10]|PRDATA[12]|PRDATA[13]|PRDATA[15]|PRDATA[16]|PRDATA[17]|PRDATA[18]|PRDATA[19]|PRDATA[21]|PRDATA[23]|PRDATA[27]|PRDATA[28]|PRDATA[29]|PRDATA[31]|PRDATA[9]|PSLVERR
+ sky130_fd_sc_hd__fill_2
X$416 \$70 \$70
+ PRDATA[10]|PRDATA[12]|PRDATA[13]|PRDATA[15]|PRDATA[16]|PRDATA[17]|PRDATA[18]|PRDATA[19]|PRDATA[21]|PRDATA[23]|PRDATA[27]|PRDATA[28]|PRDATA[29]|PRDATA[31]|PRDATA[9]|PSLVERR
+ sky130_fd_sc_hd__fill_1
X$417 \$70 \$70
+ PRDATA[10]|PRDATA[12]|PRDATA[13]|PRDATA[15]|PRDATA[16]|PRDATA[17]|PRDATA[18]|PRDATA[19]|PRDATA[21]|PRDATA[23]|PRDATA[27]|PRDATA[28]|PRDATA[29]|PRDATA[31]|PRDATA[9]|PSLVERR
+ sky130_fd_sc_hd__fill_8
X$418 \$70 \$70
+ PRDATA[10]|PRDATA[12]|PRDATA[13]|PRDATA[15]|PRDATA[16]|PRDATA[17]|PRDATA[18]|PRDATA[19]|PRDATA[21]|PRDATA[23]|PRDATA[27]|PRDATA[28]|PRDATA[29]|PRDATA[31]|PRDATA[9]|PSLVERR
+ sky130_fd_sc_hd__fill_4
X$419 \$70 \$75 \$70
+ PRDATA[10]|PRDATA[12]|PRDATA[13]|PRDATA[15]|PRDATA[16]|PRDATA[17]|PRDATA[18]|PRDATA[19]|PRDATA[21]|PRDATA[23]|PRDATA[27]|PRDATA[28]|PRDATA[29]|PRDATA[31]|PRDATA[9]|PSLVERR
+ \$153 sky130_fd_sc_hd__buf_4
X$420 \$70 \$70
+ PRDATA[10]|PRDATA[12]|PRDATA[13]|PRDATA[15]|PRDATA[16]|PRDATA[17]|PRDATA[18]|PRDATA[19]|PRDATA[21]|PRDATA[23]|PRDATA[27]|PRDATA[28]|PRDATA[29]|PRDATA[31]|PRDATA[9]|PSLVERR
+ sky130_fd_sc_hd__fill_2
X$421 \$70 \$70
+ PRDATA[10]|PRDATA[12]|PRDATA[13]|PRDATA[15]|PRDATA[16]|PRDATA[17]|PRDATA[18]|PRDATA[19]|PRDATA[21]|PRDATA[23]|PRDATA[27]|PRDATA[28]|PRDATA[29]|PRDATA[31]|PRDATA[9]|PSLVERR
+ sky130_fd_sc_hd__fill_8
X$422 \$70 VIA_via2_3_1600_480_1_5_320_320
X$423 \$70
+ PRDATA[10]|PRDATA[12]|PRDATA[13]|PRDATA[15]|PRDATA[16]|PRDATA[17]|PRDATA[18]|PRDATA[19]|PRDATA[21]|PRDATA[23]|PRDATA[27]|PRDATA[28]|PRDATA[29]|PRDATA[31]|PRDATA[9]|PSLVERR
+ sky130_fd_sc_hd__tapvpwrvgnd_1
X$424 \$70 \$70
+ PRDATA[10]|PRDATA[12]|PRDATA[13]|PRDATA[15]|PRDATA[16]|PRDATA[17]|PRDATA[18]|PRDATA[19]|PRDATA[21]|PRDATA[23]|PRDATA[27]|PRDATA[28]|PRDATA[29]|PRDATA[31]|PRDATA[9]|PSLVERR
+ sky130_fd_sc_hd__fill_8
X$425 \$70 \$70
+ PRDATA[10]|PRDATA[12]|PRDATA[13]|PRDATA[15]|PRDATA[16]|PRDATA[17]|PRDATA[18]|PRDATA[19]|PRDATA[21]|PRDATA[23]|PRDATA[27]|PRDATA[28]|PRDATA[29]|PRDATA[31]|PRDATA[9]|PSLVERR
+ sky130_fd_sc_hd__fill_2
X$426 \$70 \$162 \$70
+ PRDATA[10]|PRDATA[12]|PRDATA[13]|PRDATA[15]|PRDATA[16]|PRDATA[17]|PRDATA[18]|PRDATA[19]|PRDATA[21]|PRDATA[23]|PRDATA[27]|PRDATA[28]|PRDATA[29]|PRDATA[31]|PRDATA[9]|PSLVERR
+ \$84 sky130_fd_sc_hd__buf_4
X$427 \$70 \$70
+ PRDATA[10]|PRDATA[12]|PRDATA[13]|PRDATA[15]|PRDATA[16]|PRDATA[17]|PRDATA[18]|PRDATA[19]|PRDATA[21]|PRDATA[23]|PRDATA[27]|PRDATA[28]|PRDATA[29]|PRDATA[31]|PRDATA[9]|PSLVERR
+ sky130_fd_sc_hd__fill_8
X$428 \$70 \$70
+ PRDATA[10]|PRDATA[12]|PRDATA[13]|PRDATA[15]|PRDATA[16]|PRDATA[17]|PRDATA[18]|PRDATA[19]|PRDATA[21]|PRDATA[23]|PRDATA[27]|PRDATA[28]|PRDATA[29]|PRDATA[31]|PRDATA[9]|PSLVERR
+ sky130_fd_sc_hd__fill_8
X$429 \$70 \$70
+ PRDATA[10]|PRDATA[12]|PRDATA[13]|PRDATA[15]|PRDATA[16]|PRDATA[17]|PRDATA[18]|PRDATA[19]|PRDATA[21]|PRDATA[23]|PRDATA[27]|PRDATA[28]|PRDATA[29]|PRDATA[31]|PRDATA[9]|PSLVERR
+ sky130_fd_sc_hd__fill_2
X$430 \$70 \$70
+ PRDATA[10]|PRDATA[12]|PRDATA[13]|PRDATA[15]|PRDATA[16]|PRDATA[17]|PRDATA[18]|PRDATA[19]|PRDATA[21]|PRDATA[23]|PRDATA[27]|PRDATA[28]|PRDATA[29]|PRDATA[31]|PRDATA[9]|PSLVERR
+ sky130_fd_sc_hd__fill_1
X$431 \$70 VIA_via3_4_1600_480_1_4_400_400
X$432 \$70 VIA_via4_5_1600_480_1_4_400_400
X$433 \$70 \$70
+ PRDATA[10]|PRDATA[12]|PRDATA[13]|PRDATA[15]|PRDATA[16]|PRDATA[17]|PRDATA[18]|PRDATA[19]|PRDATA[21]|PRDATA[23]|PRDATA[27]|PRDATA[28]|PRDATA[29]|PRDATA[31]|PRDATA[9]|PSLVERR
+ sky130_fd_sc_hd__fill_2
X$434 \$70 \$70
+ PRDATA[10]|PRDATA[12]|PRDATA[13]|PRDATA[15]|PRDATA[16]|PRDATA[17]|PRDATA[18]|PRDATA[19]|PRDATA[21]|PRDATA[23]|PRDATA[27]|PRDATA[28]|PRDATA[29]|PRDATA[31]|PRDATA[9]|PSLVERR
+ sky130_fd_sc_hd__fill_4
X$435 \$70 \$70
+ PRDATA[10]|PRDATA[12]|PRDATA[13]|PRDATA[15]|PRDATA[16]|PRDATA[17]|PRDATA[18]|PRDATA[19]|PRDATA[21]|PRDATA[23]|PRDATA[27]|PRDATA[28]|PRDATA[29]|PRDATA[31]|PRDATA[9]|PSLVERR
+ sky130_fd_sc_hd__fill_1
X$436 \$70 \$198 \$70
+ PRDATA[10]|PRDATA[12]|PRDATA[13]|PRDATA[15]|PRDATA[16]|PRDATA[17]|PRDATA[18]|PRDATA[19]|PRDATA[21]|PRDATA[23]|PRDATA[27]|PRDATA[28]|PRDATA[29]|PRDATA[31]|PRDATA[9]|PSLVERR
+ \$280 sky130_fd_sc_hd__buf_4
X$437 \$70 \$70
+ PRDATA[10]|PRDATA[12]|PRDATA[13]|PRDATA[15]|PRDATA[16]|PRDATA[17]|PRDATA[18]|PRDATA[19]|PRDATA[21]|PRDATA[23]|PRDATA[27]|PRDATA[28]|PRDATA[29]|PRDATA[31]|PRDATA[9]|PSLVERR
+ sky130_fd_sc_hd__fill_8
X$438 \$70 \$70
+ PRDATA[10]|PRDATA[12]|PRDATA[13]|PRDATA[15]|PRDATA[16]|PRDATA[17]|PRDATA[18]|PRDATA[19]|PRDATA[21]|PRDATA[23]|PRDATA[27]|PRDATA[28]|PRDATA[29]|PRDATA[31]|PRDATA[9]|PSLVERR
+ sky130_fd_sc_hd__fill_8
X$439 \$70 \$70
+ PRDATA[10]|PRDATA[12]|PRDATA[13]|PRDATA[15]|PRDATA[16]|PRDATA[17]|PRDATA[18]|PRDATA[19]|PRDATA[21]|PRDATA[23]|PRDATA[27]|PRDATA[28]|PRDATA[29]|PRDATA[31]|PRDATA[9]|PSLVERR
+ sky130_fd_sc_hd__fill_1
X$440 \$70
+ PRDATA[10]|PRDATA[12]|PRDATA[13]|PRDATA[15]|PRDATA[16]|PRDATA[17]|PRDATA[18]|PRDATA[19]|PRDATA[21]|PRDATA[23]|PRDATA[27]|PRDATA[28]|PRDATA[29]|PRDATA[31]|PRDATA[9]|PSLVERR
+ sky130_fd_sc_hd__tapvpwrvgnd_1
X$441 \$70 \$70
+ PRDATA[10]|PRDATA[12]|PRDATA[13]|PRDATA[15]|PRDATA[16]|PRDATA[17]|PRDATA[18]|PRDATA[19]|PRDATA[21]|PRDATA[23]|PRDATA[27]|PRDATA[28]|PRDATA[29]|PRDATA[31]|PRDATA[9]|PSLVERR
+ sky130_fd_sc_hd__fill_8
X$442 \$70 \$70
+ PRDATA[10]|PRDATA[12]|PRDATA[13]|PRDATA[15]|PRDATA[16]|PRDATA[17]|PRDATA[18]|PRDATA[19]|PRDATA[21]|PRDATA[23]|PRDATA[27]|PRDATA[28]|PRDATA[29]|PRDATA[31]|PRDATA[9]|PSLVERR
+ sky130_fd_sc_hd__fill_8
X$443 \$70 \$70
+ PRDATA[10]|PRDATA[12]|PRDATA[13]|PRDATA[15]|PRDATA[16]|PRDATA[17]|PRDATA[18]|PRDATA[19]|PRDATA[21]|PRDATA[23]|PRDATA[27]|PRDATA[28]|PRDATA[29]|PRDATA[31]|PRDATA[9]|PSLVERR
+ sky130_fd_sc_hd__fill_8
X$444 \$70 \$70
+ PRDATA[10]|PRDATA[12]|PRDATA[13]|PRDATA[15]|PRDATA[16]|PRDATA[17]|PRDATA[18]|PRDATA[19]|PRDATA[21]|PRDATA[23]|PRDATA[27]|PRDATA[28]|PRDATA[29]|PRDATA[31]|PRDATA[9]|PSLVERR
+ sky130_fd_sc_hd__fill_8
X$445 \$70 \$70
+ PRDATA[10]|PRDATA[12]|PRDATA[13]|PRDATA[15]|PRDATA[16]|PRDATA[17]|PRDATA[18]|PRDATA[19]|PRDATA[21]|PRDATA[23]|PRDATA[27]|PRDATA[28]|PRDATA[29]|PRDATA[31]|PRDATA[9]|PSLVERR
+ sky130_fd_sc_hd__fill_8
X$446 \$70 \$70
+ PRDATA[10]|PRDATA[12]|PRDATA[13]|PRDATA[15]|PRDATA[16]|PRDATA[17]|PRDATA[18]|PRDATA[19]|PRDATA[21]|PRDATA[23]|PRDATA[27]|PRDATA[28]|PRDATA[29]|PRDATA[31]|PRDATA[9]|PSLVERR
+ sky130_fd_sc_hd__fill_4
X$447 \$70 \$70
+ PRDATA[10]|PRDATA[12]|PRDATA[13]|PRDATA[15]|PRDATA[16]|PRDATA[17]|PRDATA[18]|PRDATA[19]|PRDATA[21]|PRDATA[23]|PRDATA[27]|PRDATA[28]|PRDATA[29]|PRDATA[31]|PRDATA[9]|PSLVERR
+ sky130_fd_sc_hd__fill_2
X$448 \$70
+ PRDATA[10]|PRDATA[12]|PRDATA[13]|PRDATA[15]|PRDATA[16]|PRDATA[17]|PRDATA[18]|PRDATA[19]|PRDATA[21]|PRDATA[23]|PRDATA[27]|PRDATA[28]|PRDATA[29]|PRDATA[31]|PRDATA[9]|PSLVERR
+ \$284 \$126 \$273 \$70 sky130_fd_sc_hd__nor2b_1
X$449 \$70 \$70
+ PRDATA[10]|PRDATA[12]|PRDATA[13]|PRDATA[15]|PRDATA[16]|PRDATA[17]|PRDATA[18]|PRDATA[19]|PRDATA[21]|PRDATA[23]|PRDATA[27]|PRDATA[28]|PRDATA[29]|PRDATA[31]|PRDATA[9]|PSLVERR
+ sky130_fd_sc_hd__fill_8
X$450 \$70
+ PRDATA[10]|PRDATA[12]|PRDATA[13]|PRDATA[15]|PRDATA[16]|PRDATA[17]|PRDATA[18]|PRDATA[19]|PRDATA[21]|PRDATA[23]|PRDATA[27]|PRDATA[28]|PRDATA[29]|PRDATA[31]|PRDATA[9]|PSLVERR
+ sky130_fd_sc_hd__tapvpwrvgnd_1
X$451 \$70 \$70
+ PRDATA[10]|PRDATA[12]|PRDATA[13]|PRDATA[15]|PRDATA[16]|PRDATA[17]|PRDATA[18]|PRDATA[19]|PRDATA[21]|PRDATA[23]|PRDATA[27]|PRDATA[28]|PRDATA[29]|PRDATA[31]|PRDATA[9]|PSLVERR
+ sky130_fd_sc_hd__fill_8
X$452 \$70 \$70
+ PRDATA[10]|PRDATA[12]|PRDATA[13]|PRDATA[15]|PRDATA[16]|PRDATA[17]|PRDATA[18]|PRDATA[19]|PRDATA[21]|PRDATA[23]|PRDATA[27]|PRDATA[28]|PRDATA[29]|PRDATA[31]|PRDATA[9]|PSLVERR
+ sky130_fd_sc_hd__fill_2
X$453 \$70 \$70
+ PRDATA[10]|PRDATA[12]|PRDATA[13]|PRDATA[15]|PRDATA[16]|PRDATA[17]|PRDATA[18]|PRDATA[19]|PRDATA[21]|PRDATA[23]|PRDATA[27]|PRDATA[28]|PRDATA[29]|PRDATA[31]|PRDATA[9]|PSLVERR
+ sky130_fd_sc_hd__fill_1
X$454 \$70 \$273 \$70
+ PRDATA[10]|PRDATA[12]|PRDATA[13]|PRDATA[15]|PRDATA[16]|PRDATA[17]|PRDATA[18]|PRDATA[19]|PRDATA[21]|PRDATA[23]|PRDATA[27]|PRDATA[28]|PRDATA[29]|PRDATA[31]|PRDATA[9]|PSLVERR
+ PWRITE PENABLE PSEL sky130_fd_sc_hd__nand3_1
X$455 \$70 \$70
+ PRDATA[10]|PRDATA[12]|PRDATA[13]|PRDATA[15]|PRDATA[16]|PRDATA[17]|PRDATA[18]|PRDATA[19]|PRDATA[21]|PRDATA[23]|PRDATA[27]|PRDATA[28]|PRDATA[29]|PRDATA[31]|PRDATA[9]|PSLVERR
+ sky130_fd_sc_hd__fill_8
X$456 \$70 \$70
+ PRDATA[10]|PRDATA[12]|PRDATA[13]|PRDATA[15]|PRDATA[16]|PRDATA[17]|PRDATA[18]|PRDATA[19]|PRDATA[21]|PRDATA[23]|PRDATA[27]|PRDATA[28]|PRDATA[29]|PRDATA[31]|PRDATA[9]|PSLVERR
+ sky130_fd_sc_hd__fill_8
X$457 \$70 \$70
+ PRDATA[10]|PRDATA[12]|PRDATA[13]|PRDATA[15]|PRDATA[16]|PRDATA[17]|PRDATA[18]|PRDATA[19]|PRDATA[21]|PRDATA[23]|PRDATA[27]|PRDATA[28]|PRDATA[29]|PRDATA[31]|PRDATA[9]|PSLVERR
+ sky130_fd_sc_hd__fill_8
X$458 \$70 \$70
+ PRDATA[10]|PRDATA[12]|PRDATA[13]|PRDATA[15]|PRDATA[16]|PRDATA[17]|PRDATA[18]|PRDATA[19]|PRDATA[21]|PRDATA[23]|PRDATA[27]|PRDATA[28]|PRDATA[29]|PRDATA[31]|PRDATA[9]|PSLVERR
+ sky130_fd_sc_hd__fill_8
X$459 \$70 \$70
+ PRDATA[10]|PRDATA[12]|PRDATA[13]|PRDATA[15]|PRDATA[16]|PRDATA[17]|PRDATA[18]|PRDATA[19]|PRDATA[21]|PRDATA[23]|PRDATA[27]|PRDATA[28]|PRDATA[29]|PRDATA[31]|PRDATA[9]|PSLVERR
+ sky130_fd_sc_hd__fill_4
X$460 \$70 \$70
+ PRDATA[10]|PRDATA[12]|PRDATA[13]|PRDATA[15]|PRDATA[16]|PRDATA[17]|PRDATA[18]|PRDATA[19]|PRDATA[21]|PRDATA[23]|PRDATA[27]|PRDATA[28]|PRDATA[29]|PRDATA[31]|PRDATA[9]|PSLVERR
+ sky130_fd_sc_hd__fill_2
X$461 \$70 \$70
+ PRDATA[10]|PRDATA[12]|PRDATA[13]|PRDATA[15]|PRDATA[16]|PRDATA[17]|PRDATA[18]|PRDATA[19]|PRDATA[21]|PRDATA[23]|PRDATA[27]|PRDATA[28]|PRDATA[29]|PRDATA[31]|PRDATA[9]|PSLVERR
+ sky130_fd_sc_hd__fill_1
X$462 \$70 gpio_out[2] \$70 \$340 \$126 gpio_oe[2]
+ PRDATA[10]|PRDATA[12]|PRDATA[13]|PRDATA[15]|PRDATA[16]|PRDATA[17]|PRDATA[18]|PRDATA[19]|PRDATA[21]|PRDATA[23]|PRDATA[27]|PRDATA[28]|PRDATA[29]|PRDATA[31]|PRDATA[9]|PSLVERR
+ \$101 sky130_fd_sc_hd__a22oi_1
X$463 \$70 \$70
+ PRDATA[10]|PRDATA[12]|PRDATA[13]|PRDATA[15]|PRDATA[16]|PRDATA[17]|PRDATA[18]|PRDATA[19]|PRDATA[21]|PRDATA[23]|PRDATA[27]|PRDATA[28]|PRDATA[29]|PRDATA[31]|PRDATA[9]|PSLVERR
+ sky130_fd_sc_hd__fill_2
X$464 \$70 \$70
+ PRDATA[10]|PRDATA[12]|PRDATA[13]|PRDATA[15]|PRDATA[16]|PRDATA[17]|PRDATA[18]|PRDATA[19]|PRDATA[21]|PRDATA[23]|PRDATA[27]|PRDATA[28]|PRDATA[29]|PRDATA[31]|PRDATA[9]|PSLVERR
+ sky130_fd_sc_hd__fill_1
X$465 \$70 \$70
+ PRDATA[10]|PRDATA[12]|PRDATA[13]|PRDATA[15]|PRDATA[16]|PRDATA[17]|PRDATA[18]|PRDATA[19]|PRDATA[21]|PRDATA[23]|PRDATA[27]|PRDATA[28]|PRDATA[29]|PRDATA[31]|PRDATA[9]|PSLVERR
+ sky130_fd_sc_hd__fill_8
X$466 \$70 \$70
+ PRDATA[10]|PRDATA[12]|PRDATA[13]|PRDATA[15]|PRDATA[16]|PRDATA[17]|PRDATA[18]|PRDATA[19]|PRDATA[21]|PRDATA[23]|PRDATA[27]|PRDATA[28]|PRDATA[29]|PRDATA[31]|PRDATA[9]|PSLVERR
+ sky130_fd_sc_hd__fill_8
X$467 \$70 VIA_via2_3_1600_480_1_5_320_320
X$468 \$70
+ PRDATA[10]|PRDATA[12]|PRDATA[13]|PRDATA[15]|PRDATA[16]|PRDATA[17]|PRDATA[18]|PRDATA[19]|PRDATA[21]|PRDATA[23]|PRDATA[27]|PRDATA[28]|PRDATA[29]|PRDATA[31]|PRDATA[9]|PSLVERR
+ sky130_fd_sc_hd__tapvpwrvgnd_1
X$469 \$70 \$70
+ PRDATA[10]|PRDATA[12]|PRDATA[13]|PRDATA[15]|PRDATA[16]|PRDATA[17]|PRDATA[18]|PRDATA[19]|PRDATA[21]|PRDATA[23]|PRDATA[27]|PRDATA[28]|PRDATA[29]|PRDATA[31]|PRDATA[9]|PSLVERR
+ sky130_fd_sc_hd__fill_8
X$470 \$70 \$70
+ PRDATA[10]|PRDATA[12]|PRDATA[13]|PRDATA[15]|PRDATA[16]|PRDATA[17]|PRDATA[18]|PRDATA[19]|PRDATA[21]|PRDATA[23]|PRDATA[27]|PRDATA[28]|PRDATA[29]|PRDATA[31]|PRDATA[9]|PSLVERR
+ sky130_fd_sc_hd__fill_4
X$471 \$70 \$70
+ PRDATA[10]|PRDATA[12]|PRDATA[13]|PRDATA[15]|PRDATA[16]|PRDATA[17]|PRDATA[18]|PRDATA[19]|PRDATA[21]|PRDATA[23]|PRDATA[27]|PRDATA[28]|PRDATA[29]|PRDATA[31]|PRDATA[9]|PSLVERR
+ sky130_fd_sc_hd__fill_1
X$472 \$70 \$70
+ PRDATA[10]|PRDATA[12]|PRDATA[13]|PRDATA[15]|PRDATA[16]|PRDATA[17]|PRDATA[18]|PRDATA[19]|PRDATA[21]|PRDATA[23]|PRDATA[27]|PRDATA[28]|PRDATA[29]|PRDATA[31]|PRDATA[9]|PSLVERR
+ sky130_fd_sc_hd__fill_1
X$473 \$70 \$70
+ PRDATA[10]|PRDATA[12]|PRDATA[13]|PRDATA[15]|PRDATA[16]|PRDATA[17]|PRDATA[18]|PRDATA[19]|PRDATA[21]|PRDATA[23]|PRDATA[27]|PRDATA[28]|PRDATA[29]|PRDATA[31]|PRDATA[9]|PSLVERR
+ sky130_fd_sc_hd__fill_4
X$474 \$70 \$70
+ PRDATA[10]|PRDATA[12]|PRDATA[13]|PRDATA[15]|PRDATA[16]|PRDATA[17]|PRDATA[18]|PRDATA[19]|PRDATA[21]|PRDATA[23]|PRDATA[27]|PRDATA[28]|PRDATA[29]|PRDATA[31]|PRDATA[9]|PSLVERR
+ sky130_fd_sc_hd__fill_2
X$475 \$70
+ PRDATA[10]|PRDATA[12]|PRDATA[13]|PRDATA[15]|PRDATA[16]|PRDATA[17]|PRDATA[18]|PRDATA[19]|PRDATA[21]|PRDATA[23]|PRDATA[27]|PRDATA[28]|PRDATA[29]|PRDATA[31]|PRDATA[9]|PSLVERR
+ \$72 PRDATA[8] \$313 \$70 sky130_fd_sc_hd__nor2_2
X$476 \$70 \$70
+ PRDATA[10]|PRDATA[12]|PRDATA[13]|PRDATA[15]|PRDATA[16]|PRDATA[17]|PRDATA[18]|PRDATA[19]|PRDATA[21]|PRDATA[23]|PRDATA[27]|PRDATA[28]|PRDATA[29]|PRDATA[31]|PRDATA[9]|PSLVERR
+ sky130_fd_sc_hd__fill_8
X$477 \$70 VIA_via3_4_1600_480_1_4_400_400
X$478 \$70 VIA_via4_5_1600_480_1_4_400_400
X$479 \$70 \$70
+ PRDATA[10]|PRDATA[12]|PRDATA[13]|PRDATA[15]|PRDATA[16]|PRDATA[17]|PRDATA[18]|PRDATA[19]|PRDATA[21]|PRDATA[23]|PRDATA[27]|PRDATA[28]|PRDATA[29]|PRDATA[31]|PRDATA[9]|PSLVERR
+ sky130_fd_sc_hd__fill_8
X$480 \$70 \$70
+ PRDATA[10]|PRDATA[12]|PRDATA[13]|PRDATA[15]|PRDATA[16]|PRDATA[17]|PRDATA[18]|PRDATA[19]|PRDATA[21]|PRDATA[23]|PRDATA[27]|PRDATA[28]|PRDATA[29]|PRDATA[31]|PRDATA[9]|PSLVERR
+ sky130_fd_sc_hd__fill_8
X$481 \$70 \$70
+ PRDATA[10]|PRDATA[12]|PRDATA[13]|PRDATA[15]|PRDATA[16]|PRDATA[17]|PRDATA[18]|PRDATA[19]|PRDATA[21]|PRDATA[23]|PRDATA[27]|PRDATA[28]|PRDATA[29]|PRDATA[31]|PRDATA[9]|PSLVERR
+ sky130_fd_sc_hd__fill_4
X$482 \$70 \$70
+ PRDATA[10]|PRDATA[12]|PRDATA[13]|PRDATA[15]|PRDATA[16]|PRDATA[17]|PRDATA[18]|PRDATA[19]|PRDATA[21]|PRDATA[23]|PRDATA[27]|PRDATA[28]|PRDATA[29]|PRDATA[31]|PRDATA[9]|PSLVERR
+ sky130_fd_sc_hd__fill_1
X$483
+ PRDATA[10]|PRDATA[12]|PRDATA[13]|PRDATA[15]|PRDATA[16]|PRDATA[17]|PRDATA[18]|PRDATA[19]|PRDATA[21]|PRDATA[23]|PRDATA[27]|PRDATA[28]|PRDATA[29]|PRDATA[31]|PRDATA[9]|PSLVERR
+ \$430 \$431 \$70 \$70 sky130_fd_sc_hd__buf_6
X$484 \$70
+ PRDATA[10]|PRDATA[12]|PRDATA[13]|PRDATA[15]|PRDATA[16]|PRDATA[17]|PRDATA[18]|PRDATA[19]|PRDATA[21]|PRDATA[23]|PRDATA[27]|PRDATA[28]|PRDATA[29]|PRDATA[31]|PRDATA[9]|PSLVERR
+ sky130_fd_sc_hd__tapvpwrvgnd_1
X$485 \$70 \$70
+ PRDATA[10]|PRDATA[12]|PRDATA[13]|PRDATA[15]|PRDATA[16]|PRDATA[17]|PRDATA[18]|PRDATA[19]|PRDATA[21]|PRDATA[23]|PRDATA[27]|PRDATA[28]|PRDATA[29]|PRDATA[31]|PRDATA[9]|PSLVERR
+ sky130_fd_sc_hd__fill_8
X$486 \$70 \$70
+ PRDATA[10]|PRDATA[12]|PRDATA[13]|PRDATA[15]|PRDATA[16]|PRDATA[17]|PRDATA[18]|PRDATA[19]|PRDATA[21]|PRDATA[23]|PRDATA[27]|PRDATA[28]|PRDATA[29]|PRDATA[31]|PRDATA[9]|PSLVERR
+ sky130_fd_sc_hd__fill_4
X$487 \$70 \$504 \$70
+ PRDATA[10]|PRDATA[12]|PRDATA[13]|PRDATA[15]|PRDATA[16]|PRDATA[17]|PRDATA[18]|PRDATA[19]|PRDATA[21]|PRDATA[23]|PRDATA[27]|PRDATA[28]|PRDATA[29]|PRDATA[31]|PRDATA[9]|PSLVERR
+ \$434 sky130_fd_sc_hd__buf_4
X$488 \$70 \$70
+ PRDATA[10]|PRDATA[12]|PRDATA[13]|PRDATA[15]|PRDATA[16]|PRDATA[17]|PRDATA[18]|PRDATA[19]|PRDATA[21]|PRDATA[23]|PRDATA[27]|PRDATA[28]|PRDATA[29]|PRDATA[31]|PRDATA[9]|PSLVERR
+ sky130_fd_sc_hd__fill_1
X$489 \$70
+ PRDATA[10]|PRDATA[12]|PRDATA[13]|PRDATA[15]|PRDATA[16]|PRDATA[17]|PRDATA[18]|PRDATA[19]|PRDATA[21]|PRDATA[23]|PRDATA[27]|PRDATA[28]|PRDATA[29]|PRDATA[31]|PRDATA[9]|PSLVERR
+ sky130_fd_sc_hd__tapvpwrvgnd_1
X$490 \$70 \$70
+ PRDATA[10]|PRDATA[12]|PRDATA[13]|PRDATA[15]|PRDATA[16]|PRDATA[17]|PRDATA[18]|PRDATA[19]|PRDATA[21]|PRDATA[23]|PRDATA[27]|PRDATA[28]|PRDATA[29]|PRDATA[31]|PRDATA[9]|PSLVERR
+ sky130_fd_sc_hd__fill_8
X$491 \$70 \$70
+ PRDATA[10]|PRDATA[12]|PRDATA[13]|PRDATA[15]|PRDATA[16]|PRDATA[17]|PRDATA[18]|PRDATA[19]|PRDATA[21]|PRDATA[23]|PRDATA[27]|PRDATA[28]|PRDATA[29]|PRDATA[31]|PRDATA[9]|PSLVERR
+ sky130_fd_sc_hd__fill_8
X$492 \$70 \$70
+ PRDATA[10]|PRDATA[12]|PRDATA[13]|PRDATA[15]|PRDATA[16]|PRDATA[17]|PRDATA[18]|PRDATA[19]|PRDATA[21]|PRDATA[23]|PRDATA[27]|PRDATA[28]|PRDATA[29]|PRDATA[31]|PRDATA[9]|PSLVERR
+ sky130_fd_sc_hd__fill_4
X$493 \$70 \$70
+ PRDATA[10]|PRDATA[12]|PRDATA[13]|PRDATA[15]|PRDATA[16]|PRDATA[17]|PRDATA[18]|PRDATA[19]|PRDATA[21]|PRDATA[23]|PRDATA[27]|PRDATA[28]|PRDATA[29]|PRDATA[31]|PRDATA[9]|PSLVERR
+ sky130_fd_sc_hd__fill_2
X$494 \$70 \$70
+ PRDATA[10]|PRDATA[12]|PRDATA[13]|PRDATA[15]|PRDATA[16]|PRDATA[17]|PRDATA[18]|PRDATA[19]|PRDATA[21]|PRDATA[23]|PRDATA[27]|PRDATA[28]|PRDATA[29]|PRDATA[31]|PRDATA[9]|PSLVERR
+ sky130_fd_sc_hd__fill_1
X$495 \$70 \$70
+ PRDATA[10]|PRDATA[12]|PRDATA[13]|PRDATA[15]|PRDATA[16]|PRDATA[17]|PRDATA[18]|PRDATA[19]|PRDATA[21]|PRDATA[23]|PRDATA[27]|PRDATA[28]|PRDATA[29]|PRDATA[31]|PRDATA[9]|PSLVERR
+ sky130_fd_sc_hd__fill_8
X$496 \$70 \$70
+ PRDATA[10]|PRDATA[12]|PRDATA[13]|PRDATA[15]|PRDATA[16]|PRDATA[17]|PRDATA[18]|PRDATA[19]|PRDATA[21]|PRDATA[23]|PRDATA[27]|PRDATA[28]|PRDATA[29]|PRDATA[31]|PRDATA[9]|PSLVERR
+ sky130_fd_sc_hd__fill_8
X$497 \$70 \$70
+ PRDATA[10]|PRDATA[12]|PRDATA[13]|PRDATA[15]|PRDATA[16]|PRDATA[17]|PRDATA[18]|PRDATA[19]|PRDATA[21]|PRDATA[23]|PRDATA[27]|PRDATA[28]|PRDATA[29]|PRDATA[31]|PRDATA[9]|PSLVERR
+ sky130_fd_sc_hd__fill_1
X$498 \$70 \$70
+ PRDATA[10]|PRDATA[12]|PRDATA[13]|PRDATA[15]|PRDATA[16]|PRDATA[17]|PRDATA[18]|PRDATA[19]|PRDATA[21]|PRDATA[23]|PRDATA[27]|PRDATA[28]|PRDATA[29]|PRDATA[31]|PRDATA[9]|PSLVERR
+ sky130_fd_sc_hd__fill_2
X$499 \$70 \$70
+ PRDATA[10]|PRDATA[12]|PRDATA[13]|PRDATA[15]|PRDATA[16]|PRDATA[17]|PRDATA[18]|PRDATA[19]|PRDATA[21]|PRDATA[23]|PRDATA[27]|PRDATA[28]|PRDATA[29]|PRDATA[31]|PRDATA[9]|PSLVERR
+ sky130_fd_sc_hd__fill_1
X$500 \$70 VIA_via2_3_1600_480_1_5_320_320
X$501 \$70
+ PRDATA[10]|PRDATA[12]|PRDATA[13]|PRDATA[15]|PRDATA[16]|PRDATA[17]|PRDATA[18]|PRDATA[19]|PRDATA[21]|PRDATA[23]|PRDATA[27]|PRDATA[28]|PRDATA[29]|PRDATA[31]|PRDATA[9]|PSLVERR
+ sky130_fd_sc_hd__tapvpwrvgnd_1
X$502 \$70 \$70
+ PRDATA[10]|PRDATA[12]|PRDATA[13]|PRDATA[15]|PRDATA[16]|PRDATA[17]|PRDATA[18]|PRDATA[19]|PRDATA[21]|PRDATA[23]|PRDATA[27]|PRDATA[28]|PRDATA[29]|PRDATA[31]|PRDATA[9]|PSLVERR
+ sky130_fd_sc_hd__fill_4
X$503 \$70 \$70
+ PRDATA[10]|PRDATA[12]|PRDATA[13]|PRDATA[15]|PRDATA[16]|PRDATA[17]|PRDATA[18]|PRDATA[19]|PRDATA[21]|PRDATA[23]|PRDATA[27]|PRDATA[28]|PRDATA[29]|PRDATA[31]|PRDATA[9]|PSLVERR
+ sky130_fd_sc_hd__fill_1
X$504
+ PRDATA[10]|PRDATA[12]|PRDATA[13]|PRDATA[15]|PRDATA[16]|PRDATA[17]|PRDATA[18]|PRDATA[19]|PRDATA[21]|PRDATA[23]|PRDATA[27]|PRDATA[28]|PRDATA[29]|PRDATA[31]|PRDATA[9]|PSLVERR
+ \$148 gpio_out[4] PWDATA[4] \$453 \$70 \$70 sky130_fd_sc_hd__mux2_4
X$505 \$70 \$70
+ PRDATA[10]|PRDATA[12]|PRDATA[13]|PRDATA[15]|PRDATA[16]|PRDATA[17]|PRDATA[18]|PRDATA[19]|PRDATA[21]|PRDATA[23]|PRDATA[27]|PRDATA[28]|PRDATA[29]|PRDATA[31]|PRDATA[9]|PSLVERR
+ sky130_fd_sc_hd__fill_8
X$506 \$70 \$70
+ PRDATA[10]|PRDATA[12]|PRDATA[13]|PRDATA[15]|PRDATA[16]|PRDATA[17]|PRDATA[18]|PRDATA[19]|PRDATA[21]|PRDATA[23]|PRDATA[27]|PRDATA[28]|PRDATA[29]|PRDATA[31]|PRDATA[9]|PSLVERR
+ sky130_fd_sc_hd__fill_8
X$507 \$70 \$70
+ PRDATA[10]|PRDATA[12]|PRDATA[13]|PRDATA[15]|PRDATA[16]|PRDATA[17]|PRDATA[18]|PRDATA[19]|PRDATA[21]|PRDATA[23]|PRDATA[27]|PRDATA[28]|PRDATA[29]|PRDATA[31]|PRDATA[9]|PSLVERR
+ sky130_fd_sc_hd__fill_8
X$508 \$70 \$70
+ PRDATA[10]|PRDATA[12]|PRDATA[13]|PRDATA[15]|PRDATA[16]|PRDATA[17]|PRDATA[18]|PRDATA[19]|PRDATA[21]|PRDATA[23]|PRDATA[27]|PRDATA[28]|PRDATA[29]|PRDATA[31]|PRDATA[9]|PSLVERR
+ sky130_fd_sc_hd__fill_2
X$509 \$70 \$70
+ PRDATA[10]|PRDATA[12]|PRDATA[13]|PRDATA[15]|PRDATA[16]|PRDATA[17]|PRDATA[18]|PRDATA[19]|PRDATA[21]|PRDATA[23]|PRDATA[27]|PRDATA[28]|PRDATA[29]|PRDATA[31]|PRDATA[9]|PSLVERR
+ sky130_fd_sc_hd__fill_1
X$510 \$70 VIA_via3_4_1600_480_1_4_400_400
X$511 \$70 VIA_via4_5_1600_480_1_4_400_400
X$512 \$70 \$70
+ PRDATA[10]|PRDATA[12]|PRDATA[13]|PRDATA[15]|PRDATA[16]|PRDATA[17]|PRDATA[18]|PRDATA[19]|PRDATA[21]|PRDATA[23]|PRDATA[27]|PRDATA[28]|PRDATA[29]|PRDATA[31]|PRDATA[9]|PSLVERR
+ sky130_fd_sc_hd__fill_8
X$513 \$70 \$70
+ PRDATA[10]|PRDATA[12]|PRDATA[13]|PRDATA[15]|PRDATA[16]|PRDATA[17]|PRDATA[18]|PRDATA[19]|PRDATA[21]|PRDATA[23]|PRDATA[27]|PRDATA[28]|PRDATA[29]|PRDATA[31]|PRDATA[9]|PSLVERR
+ sky130_fd_sc_hd__fill_8
X$514 \$70 \$70
+ PRDATA[10]|PRDATA[12]|PRDATA[13]|PRDATA[15]|PRDATA[16]|PRDATA[17]|PRDATA[18]|PRDATA[19]|PRDATA[21]|PRDATA[23]|PRDATA[27]|PRDATA[28]|PRDATA[29]|PRDATA[31]|PRDATA[9]|PSLVERR
+ sky130_fd_sc_hd__fill_8
X$515 \$70 \$70
+ PRDATA[10]|PRDATA[12]|PRDATA[13]|PRDATA[15]|PRDATA[16]|PRDATA[17]|PRDATA[18]|PRDATA[19]|PRDATA[21]|PRDATA[23]|PRDATA[27]|PRDATA[28]|PRDATA[29]|PRDATA[31]|PRDATA[9]|PSLVERR
+ sky130_fd_sc_hd__fill_4
X$516 \$70 \$70
+ PRDATA[10]|PRDATA[12]|PRDATA[13]|PRDATA[15]|PRDATA[16]|PRDATA[17]|PRDATA[18]|PRDATA[19]|PRDATA[21]|PRDATA[23]|PRDATA[27]|PRDATA[28]|PRDATA[29]|PRDATA[31]|PRDATA[9]|PSLVERR
+ sky130_fd_sc_hd__fill_2
X$517 \$70
+ PRDATA[10]|PRDATA[12]|PRDATA[13]|PRDATA[15]|PRDATA[16]|PRDATA[17]|PRDATA[18]|PRDATA[19]|PRDATA[21]|PRDATA[23]|PRDATA[27]|PRDATA[28]|PRDATA[29]|PRDATA[31]|PRDATA[9]|PSLVERR
+ sky130_fd_sc_hd__tapvpwrvgnd_1
X$518 \$70 \$70
+ PRDATA[10]|PRDATA[12]|PRDATA[13]|PRDATA[15]|PRDATA[16]|PRDATA[17]|PRDATA[18]|PRDATA[19]|PRDATA[21]|PRDATA[23]|PRDATA[27]|PRDATA[28]|PRDATA[29]|PRDATA[31]|PRDATA[9]|PSLVERR
+ sky130_fd_sc_hd__fill_8
X$519 \$70 \$70
+ PRDATA[10]|PRDATA[12]|PRDATA[13]|PRDATA[15]|PRDATA[16]|PRDATA[17]|PRDATA[18]|PRDATA[19]|PRDATA[21]|PRDATA[23]|PRDATA[27]|PRDATA[28]|PRDATA[29]|PRDATA[31]|PRDATA[9]|PSLVERR
+ sky130_fd_sc_hd__fill_8
X$520 \$70 \$70
+ PRDATA[10]|PRDATA[12]|PRDATA[13]|PRDATA[15]|PRDATA[16]|PRDATA[17]|PRDATA[18]|PRDATA[19]|PRDATA[21]|PRDATA[23]|PRDATA[27]|PRDATA[28]|PRDATA[29]|PRDATA[31]|PRDATA[9]|PSLVERR
+ sky130_fd_sc_hd__fill_1
X$521 \$70
+ PRDATA[10]|PRDATA[12]|PRDATA[13]|PRDATA[15]|PRDATA[16]|PRDATA[17]|PRDATA[18]|PRDATA[19]|PRDATA[21]|PRDATA[23]|PRDATA[27]|PRDATA[28]|PRDATA[29]|PRDATA[31]|PRDATA[9]|PSLVERR
+ \$330 PRDATA[7] \$515 \$70 sky130_fd_sc_hd__nor2_2
X$522 \$70 \$70
+ PRDATA[10]|PRDATA[12]|PRDATA[13]|PRDATA[15]|PRDATA[16]|PRDATA[17]|PRDATA[18]|PRDATA[19]|PRDATA[21]|PRDATA[23]|PRDATA[27]|PRDATA[28]|PRDATA[29]|PRDATA[31]|PRDATA[9]|PSLVERR
+ sky130_fd_sc_hd__fill_1
X$523 \$70
+ PRDATA[10]|PRDATA[12]|PRDATA[13]|PRDATA[15]|PRDATA[16]|PRDATA[17]|PRDATA[18]|PRDATA[19]|PRDATA[21]|PRDATA[23]|PRDATA[27]|PRDATA[28]|PRDATA[29]|PRDATA[31]|PRDATA[9]|PSLVERR
+ \$330 PRDATA[5] \$505 \$70 sky130_fd_sc_hd__nor2_2
X$524 \$70 \$70
+ PRDATA[10]|PRDATA[12]|PRDATA[13]|PRDATA[15]|PRDATA[16]|PRDATA[17]|PRDATA[18]|PRDATA[19]|PRDATA[21]|PRDATA[23]|PRDATA[27]|PRDATA[28]|PRDATA[29]|PRDATA[31]|PRDATA[9]|PSLVERR
+ sky130_fd_sc_hd__fill_1
X$525 \$70
+ PRDATA[10]|PRDATA[12]|PRDATA[13]|PRDATA[15]|PRDATA[16]|PRDATA[17]|PRDATA[18]|PRDATA[19]|PRDATA[21]|PRDATA[23]|PRDATA[27]|PRDATA[28]|PRDATA[29]|PRDATA[31]|PRDATA[9]|PSLVERR
+ sky130_fd_sc_hd__tapvpwrvgnd_1
X$526 \$70 \$70
+ PRDATA[10]|PRDATA[12]|PRDATA[13]|PRDATA[15]|PRDATA[16]|PRDATA[17]|PRDATA[18]|PRDATA[19]|PRDATA[21]|PRDATA[23]|PRDATA[27]|PRDATA[28]|PRDATA[29]|PRDATA[31]|PRDATA[9]|PSLVERR
+ sky130_fd_sc_hd__fill_8
X$527 \$70 \$70
+ PRDATA[10]|PRDATA[12]|PRDATA[13]|PRDATA[15]|PRDATA[16]|PRDATA[17]|PRDATA[18]|PRDATA[19]|PRDATA[21]|PRDATA[23]|PRDATA[27]|PRDATA[28]|PRDATA[29]|PRDATA[31]|PRDATA[9]|PSLVERR
+ sky130_fd_sc_hd__fill_8
X$528 \$70 \$70
+ PRDATA[10]|PRDATA[12]|PRDATA[13]|PRDATA[15]|PRDATA[16]|PRDATA[17]|PRDATA[18]|PRDATA[19]|PRDATA[21]|PRDATA[23]|PRDATA[27]|PRDATA[28]|PRDATA[29]|PRDATA[31]|PRDATA[9]|PSLVERR
+ sky130_fd_sc_hd__fill_8
X$529 \$70 \$70
+ PRDATA[10]|PRDATA[12]|PRDATA[13]|PRDATA[15]|PRDATA[16]|PRDATA[17]|PRDATA[18]|PRDATA[19]|PRDATA[21]|PRDATA[23]|PRDATA[27]|PRDATA[28]|PRDATA[29]|PRDATA[31]|PRDATA[9]|PSLVERR
+ sky130_fd_sc_hd__fill_4
X$530 \$70 \$70
+ PRDATA[10]|PRDATA[12]|PRDATA[13]|PRDATA[15]|PRDATA[16]|PRDATA[17]|PRDATA[18]|PRDATA[19]|PRDATA[21]|PRDATA[23]|PRDATA[27]|PRDATA[28]|PRDATA[29]|PRDATA[31]|PRDATA[9]|PSLVERR
+ sky130_fd_sc_hd__fill_1
X$531 \$70
+ PRDATA[10]|PRDATA[12]|PRDATA[13]|PRDATA[15]|PRDATA[16]|PRDATA[17]|PRDATA[18]|PRDATA[19]|PRDATA[21]|PRDATA[23]|PRDATA[27]|PRDATA[28]|PRDATA[29]|PRDATA[31]|PRDATA[9]|PSLVERR
+ sky130_fd_sc_hd__tapvpwrvgnd_1
X$532 \$70 \$70
+ PRDATA[10]|PRDATA[12]|PRDATA[13]|PRDATA[15]|PRDATA[16]|PRDATA[17]|PRDATA[18]|PRDATA[19]|PRDATA[21]|PRDATA[23]|PRDATA[27]|PRDATA[28]|PRDATA[29]|PRDATA[31]|PRDATA[9]|PSLVERR
+ sky130_fd_sc_hd__fill_8
X$533 \$70 \$70
+ PRDATA[10]|PRDATA[12]|PRDATA[13]|PRDATA[15]|PRDATA[16]|PRDATA[17]|PRDATA[18]|PRDATA[19]|PRDATA[21]|PRDATA[23]|PRDATA[27]|PRDATA[28]|PRDATA[29]|PRDATA[31]|PRDATA[9]|PSLVERR
+ sky130_fd_sc_hd__fill_8
X$534 \$70 \$70
+ PRDATA[10]|PRDATA[12]|PRDATA[13]|PRDATA[15]|PRDATA[16]|PRDATA[17]|PRDATA[18]|PRDATA[19]|PRDATA[21]|PRDATA[23]|PRDATA[27]|PRDATA[28]|PRDATA[29]|PRDATA[31]|PRDATA[9]|PSLVERR
+ sky130_fd_sc_hd__fill_4
X$535 \$70 \$70
+ PRDATA[10]|PRDATA[12]|PRDATA[13]|PRDATA[15]|PRDATA[16]|PRDATA[17]|PRDATA[18]|PRDATA[19]|PRDATA[21]|PRDATA[23]|PRDATA[27]|PRDATA[28]|PRDATA[29]|PRDATA[31]|PRDATA[9]|PSLVERR
+ sky130_fd_sc_hd__fill_2
X$536 \$70 \$70
+ PRDATA[10]|PRDATA[12]|PRDATA[13]|PRDATA[15]|PRDATA[16]|PRDATA[17]|PRDATA[18]|PRDATA[19]|PRDATA[21]|PRDATA[23]|PRDATA[27]|PRDATA[28]|PRDATA[29]|PRDATA[31]|PRDATA[9]|PSLVERR
+ sky130_fd_sc_hd__fill_1
X$537 \$70 VIA_via2_3_1600_480_1_5_320_320
X$538 \$70 VIA_via3_4_1600_480_1_4_400_400
X$539 \$70 VIA_via4_5_1600_480_1_4_400_400
X$540 \$70 \$70
+ PRDATA[10]|PRDATA[12]|PRDATA[13]|PRDATA[15]|PRDATA[16]|PRDATA[17]|PRDATA[18]|PRDATA[19]|PRDATA[21]|PRDATA[23]|PRDATA[27]|PRDATA[28]|PRDATA[29]|PRDATA[31]|PRDATA[9]|PSLVERR
+ sky130_fd_sc_hd__fill_8
X$541 \$70 \$70
+ PRDATA[10]|PRDATA[12]|PRDATA[13]|PRDATA[15]|PRDATA[16]|PRDATA[17]|PRDATA[18]|PRDATA[19]|PRDATA[21]|PRDATA[23]|PRDATA[27]|PRDATA[28]|PRDATA[29]|PRDATA[31]|PRDATA[9]|PSLVERR
+ sky130_fd_sc_hd__fill_8
X$542 \$70 \$70
+ PRDATA[10]|PRDATA[12]|PRDATA[13]|PRDATA[15]|PRDATA[16]|PRDATA[17]|PRDATA[18]|PRDATA[19]|PRDATA[21]|PRDATA[23]|PRDATA[27]|PRDATA[28]|PRDATA[29]|PRDATA[31]|PRDATA[9]|PSLVERR
+ sky130_fd_sc_hd__fill_2
X$543 \$70 \$70
+ PRDATA[10]|PRDATA[12]|PRDATA[13]|PRDATA[15]|PRDATA[16]|PRDATA[17]|PRDATA[18]|PRDATA[19]|PRDATA[21]|PRDATA[23]|PRDATA[27]|PRDATA[28]|PRDATA[29]|PRDATA[31]|PRDATA[9]|PSLVERR
+ sky130_fd_sc_hd__fill_1
X$544 \$70 \$70
+ PRDATA[10]|PRDATA[12]|PRDATA[13]|PRDATA[15]|PRDATA[16]|PRDATA[17]|PRDATA[18]|PRDATA[19]|PRDATA[21]|PRDATA[23]|PRDATA[27]|PRDATA[28]|PRDATA[29]|PRDATA[31]|PRDATA[9]|PSLVERR
+ sky130_fd_sc_hd__fill_2
X$545 \$70
+ PRDATA[10]|PRDATA[12]|PRDATA[13]|PRDATA[15]|PRDATA[16]|PRDATA[17]|PRDATA[18]|PRDATA[19]|PRDATA[21]|PRDATA[23]|PRDATA[27]|PRDATA[28]|PRDATA[29]|PRDATA[31]|PRDATA[9]|PSLVERR
+ sky130_fd_sc_hd__tapvpwrvgnd_1
X$546 \$70 \$70
+ PRDATA[10]|PRDATA[12]|PRDATA[13]|PRDATA[15]|PRDATA[16]|PRDATA[17]|PRDATA[18]|PRDATA[19]|PRDATA[21]|PRDATA[23]|PRDATA[27]|PRDATA[28]|PRDATA[29]|PRDATA[31]|PRDATA[9]|PSLVERR
+ sky130_fd_sc_hd__fill_8
X$547 \$70 \$70
+ PRDATA[10]|PRDATA[12]|PRDATA[13]|PRDATA[15]|PRDATA[16]|PRDATA[17]|PRDATA[18]|PRDATA[19]|PRDATA[21]|PRDATA[23]|PRDATA[27]|PRDATA[28]|PRDATA[29]|PRDATA[31]|PRDATA[9]|PSLVERR
+ sky130_fd_sc_hd__fill_8
X$548 \$70 \$70
+ PRDATA[10]|PRDATA[12]|PRDATA[13]|PRDATA[15]|PRDATA[16]|PRDATA[17]|PRDATA[18]|PRDATA[19]|PRDATA[21]|PRDATA[23]|PRDATA[27]|PRDATA[28]|PRDATA[29]|PRDATA[31]|PRDATA[9]|PSLVERR
+ sky130_fd_sc_hd__fill_8
X$549 \$70 \$70
+ PRDATA[10]|PRDATA[12]|PRDATA[13]|PRDATA[15]|PRDATA[16]|PRDATA[17]|PRDATA[18]|PRDATA[19]|PRDATA[21]|PRDATA[23]|PRDATA[27]|PRDATA[28]|PRDATA[29]|PRDATA[31]|PRDATA[9]|PSLVERR
+ sky130_fd_sc_hd__fill_1
X$550 \$70
+ PRDATA[10]|PRDATA[12]|PRDATA[13]|PRDATA[15]|PRDATA[16]|PRDATA[17]|PRDATA[18]|PRDATA[19]|PRDATA[21]|PRDATA[23]|PRDATA[27]|PRDATA[28]|PRDATA[29]|PRDATA[31]|PRDATA[9]|PSLVERR
+ sky130_fd_sc_hd__tapvpwrvgnd_1
X$551 \$70 \$70
+ PRDATA[10]|PRDATA[12]|PRDATA[13]|PRDATA[15]|PRDATA[16]|PRDATA[17]|PRDATA[18]|PRDATA[19]|PRDATA[21]|PRDATA[23]|PRDATA[27]|PRDATA[28]|PRDATA[29]|PRDATA[31]|PRDATA[9]|PSLVERR
+ sky130_fd_sc_hd__fill_8
X$552 \$70 \$70
+ PRDATA[10]|PRDATA[12]|PRDATA[13]|PRDATA[15]|PRDATA[16]|PRDATA[17]|PRDATA[18]|PRDATA[19]|PRDATA[21]|PRDATA[23]|PRDATA[27]|PRDATA[28]|PRDATA[29]|PRDATA[31]|PRDATA[9]|PSLVERR
+ sky130_fd_sc_hd__fill_8
X$553 \$70 \$70
+ PRDATA[10]|PRDATA[12]|PRDATA[13]|PRDATA[15]|PRDATA[16]|PRDATA[17]|PRDATA[18]|PRDATA[19]|PRDATA[21]|PRDATA[23]|PRDATA[27]|PRDATA[28]|PRDATA[29]|PRDATA[31]|PRDATA[9]|PSLVERR
+ sky130_fd_sc_hd__fill_2
X$554 \$70 \$70
+ PRDATA[10]|PRDATA[12]|PRDATA[13]|PRDATA[15]|PRDATA[16]|PRDATA[17]|PRDATA[18]|PRDATA[19]|PRDATA[21]|PRDATA[23]|PRDATA[27]|PRDATA[28]|PRDATA[29]|PRDATA[31]|PRDATA[9]|PSLVERR
+ sky130_fd_sc_hd__fill_2
X$555 \$70
+ PRDATA[10]|PRDATA[12]|PRDATA[13]|PRDATA[15]|PRDATA[16]|PRDATA[17]|PRDATA[18]|PRDATA[19]|PRDATA[21]|PRDATA[23]|PRDATA[27]|PRDATA[28]|PRDATA[29]|PRDATA[31]|PRDATA[9]|PSLVERR
+ sky130_fd_sc_hd__tapvpwrvgnd_1
X$556 \$70 \$70
+ PRDATA[10]|PRDATA[12]|PRDATA[13]|PRDATA[15]|PRDATA[16]|PRDATA[17]|PRDATA[18]|PRDATA[19]|PRDATA[21]|PRDATA[23]|PRDATA[27]|PRDATA[28]|PRDATA[29]|PRDATA[31]|PRDATA[9]|PSLVERR
+ sky130_fd_sc_hd__fill_8
X$557 \$70 \$70
+ PRDATA[10]|PRDATA[12]|PRDATA[13]|PRDATA[15]|PRDATA[16]|PRDATA[17]|PRDATA[18]|PRDATA[19]|PRDATA[21]|PRDATA[23]|PRDATA[27]|PRDATA[28]|PRDATA[29]|PRDATA[31]|PRDATA[9]|PSLVERR
+ sky130_fd_sc_hd__fill_8
X$558 \$70 \$70
+ PRDATA[10]|PRDATA[12]|PRDATA[13]|PRDATA[15]|PRDATA[16]|PRDATA[17]|PRDATA[18]|PRDATA[19]|PRDATA[21]|PRDATA[23]|PRDATA[27]|PRDATA[28]|PRDATA[29]|PRDATA[31]|PRDATA[9]|PSLVERR
+ sky130_fd_sc_hd__fill_4
X$559 \$70 \$70
+ PRDATA[10]|PRDATA[12]|PRDATA[13]|PRDATA[15]|PRDATA[16]|PRDATA[17]|PRDATA[18]|PRDATA[19]|PRDATA[21]|PRDATA[23]|PRDATA[27]|PRDATA[28]|PRDATA[29]|PRDATA[31]|PRDATA[9]|PSLVERR
+ sky130_fd_sc_hd__fill_2
X$560 \$70 \$70
+ PRDATA[10]|PRDATA[12]|PRDATA[13]|PRDATA[15]|PRDATA[16]|PRDATA[17]|PRDATA[18]|PRDATA[19]|PRDATA[21]|PRDATA[23]|PRDATA[27]|PRDATA[28]|PRDATA[29]|PRDATA[31]|PRDATA[9]|PSLVERR
+ sky130_fd_sc_hd__fill_1
X$561 \$70 \$70
+ PRDATA[10]|PRDATA[12]|PRDATA[13]|PRDATA[15]|PRDATA[16]|PRDATA[17]|PRDATA[18]|PRDATA[19]|PRDATA[21]|PRDATA[23]|PRDATA[27]|PRDATA[28]|PRDATA[29]|PRDATA[31]|PRDATA[9]|PSLVERR
+ sky130_fd_sc_hd__fill_8
X$562 \$70 \$70
+ PRDATA[10]|PRDATA[12]|PRDATA[13]|PRDATA[15]|PRDATA[16]|PRDATA[17]|PRDATA[18]|PRDATA[19]|PRDATA[21]|PRDATA[23]|PRDATA[27]|PRDATA[28]|PRDATA[29]|PRDATA[31]|PRDATA[9]|PSLVERR
+ sky130_fd_sc_hd__fill_4
X$563 \$70 \$70
+ PRDATA[10]|PRDATA[12]|PRDATA[13]|PRDATA[15]|PRDATA[16]|PRDATA[17]|PRDATA[18]|PRDATA[19]|PRDATA[21]|PRDATA[23]|PRDATA[27]|PRDATA[28]|PRDATA[29]|PRDATA[31]|PRDATA[9]|PSLVERR
+ sky130_fd_sc_hd__fill_2
X$564 \$70 \$70
+ PRDATA[10]|PRDATA[12]|PRDATA[13]|PRDATA[15]|PRDATA[16]|PRDATA[17]|PRDATA[18]|PRDATA[19]|PRDATA[21]|PRDATA[23]|PRDATA[27]|PRDATA[28]|PRDATA[29]|PRDATA[31]|PRDATA[9]|PSLVERR
+ sky130_fd_sc_hd__fill_1
X$565 \$70 \$70
+ PRDATA[10]|PRDATA[12]|PRDATA[13]|PRDATA[15]|PRDATA[16]|PRDATA[17]|PRDATA[18]|PRDATA[19]|PRDATA[21]|PRDATA[23]|PRDATA[27]|PRDATA[28]|PRDATA[29]|PRDATA[31]|PRDATA[9]|PSLVERR
+ sky130_fd_sc_hd__fill_2
X$566 \$70 \$70
+ PRDATA[10]|PRDATA[12]|PRDATA[13]|PRDATA[15]|PRDATA[16]|PRDATA[17]|PRDATA[18]|PRDATA[19]|PRDATA[21]|PRDATA[23]|PRDATA[27]|PRDATA[28]|PRDATA[29]|PRDATA[31]|PRDATA[9]|PSLVERR
+ sky130_fd_sc_hd__fill_1
X$567 \$70 VIA_via2_3_1600_480_1_5_320_320
X$568 \$70 VIA_via3_4_1600_480_1_4_400_400
X$569 \$70 VIA_via4_5_1600_480_1_4_400_400
X$570 \$70
+ PRDATA[10]|PRDATA[12]|PRDATA[13]|PRDATA[15]|PRDATA[16]|PRDATA[17]|PRDATA[18]|PRDATA[19]|PRDATA[21]|PRDATA[23]|PRDATA[27]|PRDATA[28]|PRDATA[29]|PRDATA[31]|PRDATA[9]|PSLVERR
+ sky130_fd_sc_hd__tapvpwrvgnd_1
X$571 \$70 \$70
+ PRDATA[10]|PRDATA[12]|PRDATA[13]|PRDATA[15]|PRDATA[16]|PRDATA[17]|PRDATA[18]|PRDATA[19]|PRDATA[21]|PRDATA[23]|PRDATA[27]|PRDATA[28]|PRDATA[29]|PRDATA[31]|PRDATA[9]|PSLVERR
+ sky130_fd_sc_hd__fill_8
X$572 \$70 \$70
+ PRDATA[10]|PRDATA[12]|PRDATA[13]|PRDATA[15]|PRDATA[16]|PRDATA[17]|PRDATA[18]|PRDATA[19]|PRDATA[21]|PRDATA[23]|PRDATA[27]|PRDATA[28]|PRDATA[29]|PRDATA[31]|PRDATA[9]|PSLVERR
+ sky130_fd_sc_hd__fill_8
X$573 \$70 \$70
+ PRDATA[10]|PRDATA[12]|PRDATA[13]|PRDATA[15]|PRDATA[16]|PRDATA[17]|PRDATA[18]|PRDATA[19]|PRDATA[21]|PRDATA[23]|PRDATA[27]|PRDATA[28]|PRDATA[29]|PRDATA[31]|PRDATA[9]|PSLVERR
+ sky130_fd_sc_hd__fill_8
X$574 \$70 \$70
+ PRDATA[10]|PRDATA[12]|PRDATA[13]|PRDATA[15]|PRDATA[16]|PRDATA[17]|PRDATA[18]|PRDATA[19]|PRDATA[21]|PRDATA[23]|PRDATA[27]|PRDATA[28]|PRDATA[29]|PRDATA[31]|PRDATA[9]|PSLVERR
+ sky130_fd_sc_hd__fill_2
X$575 \$72 VIA_M1M2_PR
X$576 \$72 VIA_M1M2_PR
X$577 \$72 VIA_M1M2_PR
X$578 \$72 VIA_M1M2_PR
X$579 \$72 VIA_M1M2_PR
X$580 \$72 VIA_M2M3_PR
X$581 \$72 VIA_M1M2_PR
X$582 \$72 VIA_M1M2_PR
X$583 \$72 VIA_M1M2_PR
X$584 \$72 VIA_L1M1_PR_MR
X$585 \$72 VIA_L1M1_PR_MR
X$586 \$72 VIA_L1M1_PR_MR
X$587 \$72 VIA_M1M2_PR
X$588 \$72 VIA_M2M3_PR
X$589 \$72 VIA_L1M1_PR_MR
X$590 \$72 VIA_L1M1_PR_MR
X$591 \$72 VIA_L1M1_PR_MR
X$592 \$72 VIA_M1M2_PR
X$593 \$72 VIA_L1M1_PR_MR
X$594 \$72 VIA_L1M1_PR_MR
X$595 \$72 VIA_L1M1_PR_MR
X$596 \$75 VIA_M1M2_PR
X$597 \$75 VIA_L1M1_PR_MR
X$598 \$75 VIA_L1M1_PR_MR
X$599 \$75 VIA_M1M2_PR
X$600 \$76 VIA_M1M2_PR
X$601 \$76 VIA_L1M1_PR_MR
X$602 \$76 VIA_M1M2_PR
X$603 \$76 VIA_L1M1_PR_MR
X$604 \$78 VIA_M1M2_PR
X$605 \$78 VIA_M1M2_PR
X$606 \$78 VIA_M1M2_PR
X$607 \$78 VIA_M1M2_PR
X$608 \$78 VIA_M1M2_PR
X$609 \$78 VIA_M1M2_PR
X$610 \$78 VIA_M1M2_PR
X$611 \$78 VIA_M1M2_PR
X$612 \$78 VIA_L1M1_PR_MR
X$613 \$78 VIA_L1M1_PR_MR
X$614 \$78 VIA_M1M2_PR
X$615 \$78 VIA_L1M1_PR_MR
X$616 \$78 VIA_L1M1_PR_MR
X$617 \$78 VIA_M1M2_PR
X$618 \$78 VIA_L1M1_PR_MR
X$619 \$78 VIA_L1M1_PR_MR
X$620 \$78 VIA_M1M2_PR
X$621 \$78 VIA_L1M1_PR_MR
X$622 \$78 VIA_L1M1_PR_MR
X$623 \$78 VIA_L1M1_PR_MR
X$624 \$82 VIA_L1M1_PR_MR
X$625 \$82 VIA_L1M1_PR_MR
X$626 \$84 VIA_M1M2_PR
X$627 \$84 VIA_M1M2_PR
X$628 \$84 VIA_L1M1_PR_MR
X$629 \$84 VIA_L1M1_PR_MR
X$630 \$89 VIA_M1M2_PR
X$631 \$89 VIA_L1M1_PR_MR
X$632 \$89 VIA_L1M1_PR_MR
X$633 \$89 VIA_M1M2_PR
X$634 \$101 VIA_M1M2_PR
X$635 \$101 VIA_M1M2_PR
X$636 \$101 VIA_M1M2_PR
X$637 \$101 VIA_M1M2_PR
X$638 \$101 VIA_M1M2_PR
X$639 \$101 VIA_M1M2_PR
X$640 \$101 VIA_M1M2_PR
X$641 \$101 VIA_M1M2_PR
X$642 \$101 VIA_L1M1_PR_MR
X$643 \$101 VIA_L1M1_PR_MR
X$644 \$101 VIA_M1M2_PR
X$645 \$101 VIA_L1M1_PR_MR
X$646 \$101 VIA_L1M1_PR_MR
X$647 \$101 VIA_L1M1_PR_MR
X$648 \$101 VIA_L1M1_PR_MR
X$649 \$101 VIA_M1M2_PR
X$650 \$101 VIA_L1M1_PR_MR
X$651 \$101 VIA_L1M1_PR_MR
X$652 \$101 VIA_L1M1_PR_MR
X$653 \$101 VIA_M1M2_PR
X$654 \$101 VIA_L1M1_PR_MR
X$655 \$101 VIA_L1M1_PR_MR
X$656 \$117 VIA_M1M2_PR
X$657 \$117 VIA_L1M1_PR_MR
X$658 \$117 VIA_M1M2_PR
X$659 \$117 VIA_L1M1_PR_MR
X$660 \$126 VIA_M1M2_PR
X$661 \$126 VIA_M1M2_PR
X$662 \$126 VIA_M1M2_PR
X$663 \$126 VIA_M1M2_PR
X$664 \$126 VIA_M1M2_PR
X$665 \$126 VIA_M1M2_PR
X$666 \$126 VIA_M1M2_PR
X$667 \$126 VIA_M1M2_PR
X$668 \$126 VIA_L1M1_PR_MR
X$669 \$126 VIA_L1M1_PR_MR
X$670 \$126 VIA_L1M1_PR_MR
X$671 \$126 VIA_L1M1_PR_MR
X$672 \$126 VIA_M1M2_PR
X$673 \$126 VIA_M2M3_PR
X$674 \$126 VIA_L1M1_PR_MR
X$675 \$126 VIA_M1M2_PR
X$676 \$126 VIA_L1M1_PR_MR
X$677 \$126 VIA_M1M2_PR
X$678 \$126 VIA_M2M3_PR
X$679 \$126 VIA_L1M1_PR_MR
X$680 \$126 VIA_L1M1_PR_MR
X$681 \$126 VIA_M1M2_PR
X$682 \$126 VIA_L1M1_PR_MR
X$683 \$126 VIA_L1M1_PR_MR
X$684 \$126 VIA_M1M2_PR
X$685 \$132 VIA_M1M2_PR
X$686 \$132 VIA_L1M1_PR_MR
X$687 \$132 VIA_M1M2_PR
X$688 \$132 VIA_L1M1_PR_MR
X$689 \$135 VIA_M1M2_PR
X$690 \$135 VIA_L1M1_PR_MR
X$691 \$135 VIA_M1M2_PR
X$692 \$135 VIA_L1M1_PR_MR
X$693 \$142 VIA_M1M2_PR
X$694 \$142 VIA_L1M1_PR_MR
X$695 \$142 VIA_M1M2_PR
X$696 \$142 VIA_L1M1_PR_MR
X$697 \$147 VIA_M1M2_PR
X$698 \$147 VIA_M1M2_PR
X$699 \$147 VIA_L1M1_PR_MR
X$700 \$147 VIA_L1M1_PR_MR
X$701 \$148 VIA_M1M2_PR
X$702 \$148 VIA_M1M2_PR
X$703 \$148 VIA_M1M2_PR
X$704 \$148 VIA_M1M2_PR
X$705 \$148 VIA_M1M2_PR
X$706 \$148 VIA_M1M2_PR
X$707 \$148 VIA_M1M2_PR
X$708 \$148 VIA_M1M2_PR
X$709 \$148 VIA_M1M2_PR
X$710 \$148 VIA_M1M2_PR
X$711 \$148 VIA_L1M1_PR_MR
X$712 \$148 VIA_L1M1_PR_MR
X$713 \$148 VIA_L1M1_PR_MR
X$714 \$148 VIA_L1M1_PR_MR
X$715 \$148 VIA_L1M1_PR_MR
X$716 \$148 VIA_L1M1_PR_MR
X$717 \$148 VIA_M1M2_PR
X$718 \$148 VIA_L1M1_PR_MR
X$719 \$148 VIA_L1M1_PR_MR
X$720 \$148 VIA_L1M1_PR_MR
X$721 \$151 VIA_L1M1_PR_MR
X$722 \$151 VIA_M1M2_PR
X$723 \$151 VIA_L1M1_PR_MR
X$724 \$151 VIA_M1M2_PR
X$725 \$153 VIA_M1M2_PR
X$726 \$153 VIA_L1M1_PR_MR
X$727 \$153 VIA_L1M1_PR_MR
X$728 \$153 VIA_M1M2_PR
X$729 \$162 VIA_M1M2_PR
X$730 \$162 VIA_L1M1_PR_MR
X$731 \$162 VIA_M1M2_PR
X$732 \$162 VIA_L1M1_PR_MR
X$733 gpio_oe[6] VIA_M2M3_PR
X$734 gpio_oe[6] VIA_M1M2_PR
X$735 gpio_oe[6] VIA_M1M2_PR
X$736 gpio_oe[6] VIA_M1M2_PR
X$737 gpio_oe[6] VIA_M1M2_PR
X$738 gpio_oe[6] VIA_L1M1_PR_MR
X$739 gpio_oe[6] VIA_L1M1_PR_MR
X$740 gpio_oe[6] VIA_L1M1_PR_MR
X$741 \$179 VIA_M1M2_PR
X$742 \$179 VIA_L1M1_PR_MR
X$743 \$179 VIA_L1M1_PR_MR
X$744 \$179 VIA_M1M2_PR
X$745 \$182 VIA_M1M2_PR
X$746 \$182 VIA_L1M1_PR_MR
X$747 \$182 VIA_L1M1_PR_MR
X$748 \$182 VIA_M1M2_PR
X$749 gpio_in[3] VIA_M2M3_PR
X$750 gpio_in[3] VIA_M1M2_PR
X$751 gpio_in[3] VIA_L1M1_PR_MR
X$752 PRDATA[3] VIA_M1M2_PR
X$753 PRDATA[3] VIA_M2M3_PR
X$754 PRDATA[3] VIA_L1M1_PR_MR
X$755 \$198 VIA_M1M2_PR
X$756 \$198 VIA_L1M1_PR_MR
X$757 \$198 VIA_M1M2_PR
X$758 \$198 VIA_L1M1_PR_MR
X$759 PWDATA[6] VIA_M1M2_PR
X$760 PWDATA[6] VIA_L1M1_PR_MR
X$761 PWDATA[6] VIA_M1M2_PR
X$762 PWDATA[6] VIA_M2M3_PR
X$763 PWDATA[6] VIA_L1M1_PR_MR
X$764 \$204 VIA_M1M2_PR
X$765 \$204 VIA_M1M2_PR
X$766 \$204 VIA_L1M1_PR_MR
X$767 \$204 VIA_L1M1_PR_MR
X$768 \$213 VIA_L1M1_PR_MR
X$769 \$213 VIA_L1M1_PR_MR
X$770 PWRITE VIA_M2M3_PR
X$771 PWRITE VIA_M1M2_PR
X$772 PWRITE VIA_M1M2_PR
X$773 PWRITE VIA_L1M1_PR_MR
X$774 PWRITE VIA_L1M1_PR_MR
X$775 \$215 VIA_L1M1_PR_MR
X$776 \$215 VIA_L1M1_PR_MR
X$777 \$223 VIA_M1M2_PR
X$778 \$223 VIA_M1M2_PR
X$779 \$223 VIA_M1M2_PR
X$780 \$223 VIA_L1M1_PR_MR
X$781 \$223 VIA_L1M1_PR_MR
X$782 \$223 VIA_M1M2_PR
X$783 \$223 VIA_L1M1_PR_MR
X$784 \$223 VIA_M1M2_PR
X$785 gpio_out[6] VIA_M2M3_PR
X$786 gpio_out[6] VIA_M1M2_PR
X$787 gpio_out[6] VIA_M1M2_PR
X$788 gpio_out[6] VIA_M1M2_PR
X$789 gpio_out[6] VIA_L1M1_PR_MR
X$790 gpio_out[6] VIA_L1M1_PR_MR
X$791 gpio_out[6] VIA_L1M1_PR_MR
X$792 gpio_out[6] VIA_L1M1_PR_MR
X$793 \$230 VIA_L1M1_PR_MR
X$794 \$230 VIA_L1M1_PR_MR
X$795 PENABLE VIA_M2M3_PR
X$796 PENABLE VIA_M1M2_PR
X$797 PENABLE VIA_L1M1_PR_MR
X$798 PENABLE VIA_M1M2_PR
X$799 PENABLE VIA_L1M1_PR_MR
X$800 \$241 VIA_L1M1_PR_MR
X$801 \$241 VIA_L1M1_PR_MR
X$802 \$245 VIA_M1M2_PR
X$803 \$245 VIA_L1M1_PR_MR
X$804 \$245 VIA_M1M2_PR
X$805 \$245 VIA_L1M1_PR_MR
X$806 \$255 VIA_L1M1_PR_MR
X$807 \$255 VIA_L1M1_PR_MR
X$808 PREADY VIA_M2M3_PR
X$809 PREADY VIA_M1M2_PR
X$810 PREADY VIA_L1M1_PR_MR
X$811 PREADY VIA_M1M2_PR
X$812 PREADY VIA_L1M1_PR_MR
X$813 PSEL VIA_M2M3_PR
X$814 PSEL VIA_L1M1_PR_MR
X$815 PSEL VIA_M1M2_PR
X$816 PSEL VIA_M2M3_PR
X$817 PSEL VIA_L1M1_PR_MR
X$818 PSEL VIA_M1M2_PR
X$819 \$261 VIA_L1M1_PR_MR
X$820 \$261 VIA_L1M1_PR_MR
X$821 \$265 VIA_M1M2_PR
X$822 \$265 VIA_L1M1_PR_MR
X$823 \$265 VIA_L1M1_PR_MR
X$824 \$265 VIA_M1M2_PR
X$825 \$273 VIA_M1M2_PR
X$826 \$273 VIA_L1M1_PR_MR
X$827 \$273 VIA_M1M2_PR
X$828 \$273 VIA_L1M1_PR_MR
X$829 \$273 VIA_L1M1_PR_MR
X$830 PADDR[3] VIA_M2M3_PR
X$831 PADDR[3] VIA_M1M2_PR
X$832 PADDR[3] VIA_M1M2_PR
X$833 PADDR[3] VIA_M1M2_PR
X$834 PADDR[3] VIA_L1M1_PR_MR
X$835 PADDR[3] VIA_L1M1_PR_MR
X$836 PADDR[3] VIA_L1M1_PR_MR
X$837 PADDR[3] VIA_M1M2_PR
X$838 PADDR[3] VIA_L1M1_PR_MR
X$839 PRDATA[8] VIA_M2M3_PR
X$840 PRDATA[8] VIA_M1M2_PR
X$841 PRDATA[8] VIA_L1M1_PR_MR
X$842 \$280 VIA_L1M1_PR_MR
X$843 \$280 VIA_M1M2_PR
X$844 \$280 VIA_L1M1_PR_MR
X$845 \$280 VIA_M1M2_PR
X$846 \$284 VIA_M1M2_PR
X$847 \$284 VIA_L1M1_PR_MR
X$848 \$284 VIA_L1M1_PR_MR
X$849 \$284 VIA_M1M2_PR
X$850 gpio_in[2] VIA_L1M1_PR_MR
X$851 gpio_in[2] VIA_M1M2_PR
X$852 gpio_in[2] VIA_M2M3_PR
X$853 PRDATA[30] VIA_M2M3_PR
X$854 PRDATA[30] VIA_L1M1_PR_MR
X$855 PRDATA[30] VIA_M1M2_PR
X$856 PRDATA[2] VIA_M1M2_PR
X$857 PRDATA[2] VIA_M2M3_PR
X$858 PRDATA[2] VIA_L1M1_PR_MR
X$859 gpio_out[2] VIA_M2M3_PR
X$860 gpio_out[2] VIA_M1M2_PR
X$861 gpio_out[2] VIA_M1M2_PR
X$862 gpio_out[2] VIA_M1M2_PR
X$863 gpio_out[2] VIA_L1M1_PR_MR
X$864 gpio_out[2] VIA_M1M2_PR
X$865 gpio_out[2] VIA_L1M1_PR_MR
X$866 gpio_out[2] VIA_L1M1_PR_MR
X$867 gpio_out[2] VIA_L1M1_PR_MR
X$868 \$313 VIA_M1M2_PR
X$869 \$313 VIA_M1M2_PR
X$870 \$313 VIA_M1M2_PR
X$871 \$313 VIA_L1M1_PR_MR
X$872 \$313 VIA_M1M2_PR
X$873 \$313 VIA_L1M1_PR_MR
X$874 \$313 VIA_M1M2_PR
X$875 \$313 VIA_L1M1_PR_MR
X$876 \$313 VIA_M1M2_PR
X$877 \$313 VIA_L1M1_PR_MR
X$878 \$313 VIA_M1M2_PR
X$879 \$313 VIA_L1M1_PR_MR
X$880 \$313 VIA_M1M2_PR
X$881 \$313 VIA_L1M1_PR_MR
X$882 \$313 VIA_L1M1_PR_MR
X$883 \$313 VIA_M1M2_PR
X$884 \$313 VIA_L1M1_PR_MR
X$885 \$313 VIA_L1M1_PR_MR
X$886 \$313 VIA_L1M1_PR_MR
X$887 \$313 VIA_M1M2_PR
X$888 PADDR[5] VIA_M2M3_PR
X$889 PADDR[5] VIA_M1M2_PR
X$890 PADDR[5] VIA_L1M1_PR_MR
X$891 PADDR[5] VIA_M1M2_PR
X$892 PADDR[5] VIA_L1M1_PR_MR
X$893 PADDR[5] VIA_M1M2_PR
X$894 PADDR[5] VIA_L1M1_PR_MR
X$895 PADDR[5] VIA_L1M1_PR_MR
X$896 gpio_oe[2] VIA_M2M3_PR
X$897 gpio_oe[2] VIA_M1M2_PR
X$898 gpio_oe[2] VIA_M1M2_PR
X$899 gpio_oe[2] VIA_M1M2_PR
X$900 gpio_oe[2] VIA_M1M2_PR
X$901 gpio_oe[2] VIA_L1M1_PR_MR
X$902 gpio_oe[2] VIA_L1M1_PR_MR
X$903 gpio_oe[2] VIA_L1M1_PR_MR
X$904 gpio_oe[2] VIA_L1M1_PR_MR
X$905 \$319 VIA_M1M2_PR
X$906 \$319 VIA_L1M1_PR_MR
X$907 \$319 VIA_M1M2_PR
X$908 \$319 VIA_L1M1_PR_MR
X$909 PADDR[4] VIA_M1M2_PR
X$910 PADDR[4] VIA_M1M2_PR
X$911 PADDR[4] VIA_L1M1_PR_MR
X$912 PADDR[4] VIA_M1M2_PR
X$913 PADDR[4] VIA_L1M1_PR_MR
X$914 PADDR[4] VIA_M1M2_PR
X$915 PADDR[4] VIA_L1M1_PR_MR
X$916 PADDR[4] VIA_L1M1_PR_MR
X$917 \$330 VIA_M1M2_PR
X$918 \$330 VIA_M1M2_PR
X$919 \$330 VIA_L1M1_PR_MR
X$920 \$330 VIA_M1M2_PR
X$921 \$330 VIA_L1M1_PR_MR
X$922 \$330 VIA_L1M1_PR_MR
X$923 \$330 VIA_M1M2_PR
X$924 \$330 VIA_L1M1_PR_MR
X$925 \$330 VIA_L1M1_PR_MR
X$926 \$330 VIA_L1M1_PR_MR
X$927 \$330 VIA_L1M1_PR_MR
X$928 \$330 VIA_M1M2_PR
X$929 \$330 VIA_L1M1_PR_MR
X$930 \$330 VIA_L1M1_PR_MR
X$931 \$330 VIA_L1M1_PR_MR
X$932 \$330 VIA_M1M2_PR
X$933 \$330 VIA_L1M1_PR_MR
X$934 \$330 VIA_M1M2_PR
X$935 PRDATA[20] VIA_L1M1_PR_MR
X$936 PRDATA[20] VIA_M1M2_PR
X$937 PRDATA[20] VIA_M2M3_PR
X$938 \$335 VIA_L1M1_PR_MR
X$939 \$335 VIA_L1M1_PR_MR
X$940 \$340 VIA_L1M1_PR_MR
X$941 \$340 VIA_M1M2_PR
X$942 \$340 VIA_L1M1_PR_MR
X$943 \$340 VIA_M1M2_PR
X$944 PWDATA[2] VIA_M2M3_PR
X$945 PWDATA[2] VIA_M1M2_PR
X$946 PWDATA[2] VIA_L1M1_PR_MR
X$947 PWDATA[2] VIA_L1M1_PR_MR
X$948 PWDATA[2] VIA_M1M2_PR
X$949 \$346 VIA_M1M2_PR
X$950 \$346 VIA_M1M2_PR
X$951 \$346 VIA_M1M2_PR
X$952 \$346 VIA_M1M2_PR
X$953 \$346 VIA_M1M2_PR
X$954 \$346 VIA_L1M1_PR_MR
X$955 \$346 VIA_M1M2_PR
X$956 \$346 VIA_L1M1_PR_MR
X$957 \$346 VIA_M1M2_PR
X$958 \$346 VIA_L1M1_PR_MR
X$959 \$346 VIA_L1M1_PR_MR
X$960 \$346 VIA_M1M2_PR
X$961 \$346 VIA_L1M1_PR_MR
X$962 \$346 VIA_L1M1_PR_MR
X$963 \$346 VIA_M1M2_PR
X$964 \$346 VIA_L1M1_PR_MR
X$965 \$346 VIA_L1M1_PR_MR
X$966 \$346 VIA_M1M2_PR
X$967 \$346 VIA_L1M1_PR_MR
X$968 PRDATA[26] VIA_M2M3_PR
X$969 PRDATA[26] VIA_M1M2_PR
X$970 PRDATA[26] VIA_L1M1_PR_MR
X$971 \$362 VIA_M1M2_PR
X$972 \$362 VIA_M1M2_PR
X$973 \$362 VIA_M1M2_PR
X$974 \$362 VIA_L1M1_PR_MR
X$975 \$362 VIA_L1M1_PR_MR
X$976 \$362 VIA_L1M1_PR_MR
X$977 \$362 VIA_L1M1_PR_MR
X$978 PRDATA[22] VIA_L1M1_PR_MR
X$979 PRDATA[22] VIA_M1M2_PR
X$980 PRDATA[22] VIA_M2M3_PR
X$981 PRDATA[14] VIA_M2M3_PR
X$982 PRDATA[14] VIA_L1M1_PR_MR
X$983 PRDATA[14] VIA_M1M2_PR
X$984 \$372 VIA_L1M1_PR_MR
X$985 \$372 VIA_M1M2_PR
X$986 \$372 VIA_L1M1_PR_MR
X$987 \$372 VIA_M1M2_PR
X$988 PRDATA[24] VIA_L1M1_PR_MR
X$989 PRDATA[24] VIA_M1M2_PR
X$990 PRDATA[24] VIA_M2M3_PR
X$991 PRDATA[25] VIA_M2M3_PR
X$992 PRDATA[25] VIA_L1M1_PR_MR
X$993 PRDATA[25] VIA_M1M2_PR
X$994 PRDATA[4] VIA_M2M3_PR
X$995 PRDATA[4] VIA_M1M2_PR
X$996 PRDATA[4] VIA_L1M1_PR_MR
X$997 \$392 VIA_L1M1_PR_MR
X$998 \$392 VIA_M1M2_PR
X$999 \$392 VIA_L1M1_PR_MR
X$1000 \$392 VIA_M1M2_PR
X$1001 \$393 VIA_L1M1_PR_MR
X$1002 \$393 VIA_M1M2_PR
X$1003 \$393 VIA_L1M1_PR_MR
X$1004 \$393 VIA_M1M2_PR
X$1005 \$395 VIA_M1M2_PR
X$1006 \$395 VIA_M1M2_PR
X$1007 \$395 VIA_L1M1_PR_MR
X$1008 \$395 VIA_L1M1_PR_MR
X$1009 \$399 VIA_M1M2_PR
X$1010 \$399 VIA_M1M2_PR
X$1011 \$399 VIA_L1M1_PR_MR
X$1012 \$399 VIA_L1M1_PR_MR
X$1013 \$406 VIA_L1M1_PR_MR
X$1014 \$406 VIA_L1M1_PR_MR
X$1015 PRDATA[11] VIA_M2M3_PR
X$1016 PRDATA[11] VIA_L1M1_PR_MR
X$1017 PRDATA[11] VIA_M1M2_PR
X$1018 gpio_out[5] VIA_M1M2_PR
X$1019 gpio_out[5] VIA_M1M2_PR
X$1020 gpio_out[5] VIA_M1M2_PR
X$1021 gpio_out[5] VIA_L1M1_PR_MR
X$1022 gpio_out[5] VIA_L1M1_PR_MR
X$1023 gpio_out[5] VIA_M1M2_PR
X$1024 gpio_out[5] VIA_L1M1_PR_MR
X$1025 gpio_out[5] VIA_M1M2_PR
X$1026 \$418 VIA_M1M2_PR
X$1027 \$418 VIA_L1M1_PR_MR
X$1028 \$418 VIA_L1M1_PR_MR
X$1029 \$418 VIA_M1M2_PR
X$1030 gpio_oe[4] VIA_M1M2_PR
X$1031 gpio_oe[4] VIA_M1M2_PR
X$1032 gpio_oe[4] VIA_L1M1_PR_MR
X$1033 gpio_oe[4] VIA_L1M1_PR_MR
X$1034 gpio_oe[4] VIA_M1M2_PR
X$1035 gpio_oe[4] VIA_L1M1_PR_MR
X$1036 \$430 VIA_M1M2_PR
X$1037 \$430 VIA_M1M2_PR
X$1038 \$430 VIA_L1M1_PR_MR
X$1039 \$430 VIA_L1M1_PR_MR
X$1040 \$431 VIA_M1M2_PR
X$1041 \$431 VIA_L1M1_PR_MR
X$1042 \$431 VIA_M1M2_PR
X$1043 \$431 VIA_L1M1_PR_MR
X$1044 gpio_oe[7] VIA_M1M2_PR
X$1045 gpio_oe[7] VIA_M1M2_PR
X$1046 gpio_oe[7] VIA_M1M2_PR
X$1047 gpio_oe[7] VIA_L1M1_PR_MR
X$1048 gpio_oe[7] VIA_M1M2_PR
X$1049 gpio_oe[7] VIA_L1M1_PR_MR
X$1050 gpio_oe[7] VIA_L1M1_PR_MR
X$1051 \$434 VIA_M1M2_PR
X$1052 \$434 VIA_M1M2_PR
X$1053 \$434 VIA_L1M1_PR_MR
X$1054 \$434 VIA_L1M1_PR_MR
X$1055 \$435 VIA_M1M2_PR
X$1056 \$435 VIA_L1M1_PR_MR
X$1057 \$435 VIA_M1M2_PR
X$1058 \$435 VIA_L1M1_PR_MR
X$1059 PCLK VIA_M2M3_PR
X$1060 PCLK VIA_L1M1_PR_MR
X$1061 PCLK VIA_M1M2_PR
X$1062 gpio_oe[5] VIA_M1M2_PR
X$1063 gpio_oe[5] VIA_M1M2_PR
X$1064 gpio_oe[5] VIA_M1M2_PR
X$1065 gpio_oe[5] VIA_M1M2_PR
X$1066 gpio_oe[5] VIA_M1M2_PR
X$1067 gpio_oe[5] VIA_M1M2_PR
X$1068 gpio_oe[5] VIA_L1M1_PR_MR
X$1069 gpio_oe[5] VIA_L1M1_PR_MR
X$1070 gpio_oe[5] VIA_L1M1_PR_MR
X$1071 gpio_oe[5] VIA_M1M2_PR
X$1072 \$446 VIA_M1M2_PR
X$1073 \$446 VIA_L1M1_PR_MR
X$1074 \$446 VIA_L1M1_PR_MR
X$1075 \$446 VIA_M1M2_PR
X$1076 PWDATA[4] VIA_M1M2_PR
X$1077 PWDATA[4] VIA_L1M1_PR_MR
X$1078 PWDATA[4] VIA_L1M1_PR_MR
X$1079 \$451 VIA_M1M2_PR
X$1080 \$451 VIA_L1M1_PR_MR
X$1081 \$451 VIA_M1M2_PR
X$1082 \$451 VIA_L1M1_PR_MR
X$1083 \$453 VIA_M1M2_PR
X$1084 \$453 VIA_M1M2_PR
X$1085 \$453 VIA_L1M1_PR_MR
X$1086 \$453 VIA_L1M1_PR_MR
X$1087 gpio_out[4] VIA_M1M2_PR
X$1088 gpio_out[4] VIA_M1M2_PR
X$1089 gpio_out[4] VIA_M1M2_PR
X$1090 gpio_out[4] VIA_L1M1_PR_MR
X$1091 gpio_out[4] VIA_L1M1_PR_MR
X$1092 gpio_out[4] VIA_L1M1_PR_MR
X$1093 gpio_out[4] VIA_M1M2_PR
X$1094 \$465 VIA_L1M1_PR_MR
X$1095 \$465 VIA_L1M1_PR_MR
X$1096 PWDATA[7] VIA_M1M2_PR
X$1097 PWDATA[7] VIA_L1M1_PR_MR
X$1098 PWDATA[7] VIA_L1M1_PR_MR
X$1099 PWDATA[5] VIA_M1M2_PR
X$1100 PWDATA[5] VIA_M1M2_PR
X$1101 PWDATA[5] VIA_L1M1_PR_MR
X$1102 PWDATA[5] VIA_L1M1_PR_MR
X$1103 \$479 VIA_M1M2_PR
X$1104 \$479 VIA_M1M2_PR
X$1105 \$479 VIA_L1M1_PR_MR
X$1106 \$479 VIA_L1M1_PR_MR
X$1107 gpio_out[7] VIA_M1M2_PR
X$1108 gpio_out[7] VIA_L1M1_PR_MR
X$1109 gpio_out[7] VIA_M1M2_PR
X$1110 gpio_out[7] VIA_L1M1_PR_MR
X$1111 gpio_out[7] VIA_M1M2_PR
X$1112 gpio_out[7] VIA_L1M1_PR_MR
X$1113 gpio_out[7] VIA_L1M1_PR_MR
X$1114 gpio_in[5] VIA_M1M2_PR
X$1115 gpio_in[5] VIA_M1M2_PR
X$1116 gpio_in[5] VIA_M1M2_PR
X$1117 gpio_in[5] VIA_L1M1_PR_MR
X$1118 \$504 VIA_M1M2_PR
X$1119 \$504 VIA_L1M1_PR_MR
X$1120 \$504 VIA_L1M1_PR_MR
X$1121 \$504 VIA_M1M2_PR
X$1122 \$505 VIA_M1M2_PR
X$1123 \$505 VIA_L1M1_PR_MR
X$1124 \$505 VIA_M1M2_PR
X$1125 \$505 VIA_L1M1_PR_MR
X$1126 gpio_in[7] VIA_M1M2_PR
X$1127 gpio_in[7] VIA_L1M1_PR_MR
X$1128 \$515 VIA_M1M2_PR
X$1129 \$515 VIA_M1M2_PR
X$1130 \$515 VIA_L1M1_PR_MR
X$1131 \$515 VIA_L1M1_PR_MR
X$1132 gpio_in[4] VIA_L1M1_PR_MR
X$1133 gpio_in[4] VIA_M1M2_PR
X$1134 PRDATA[7] VIA_M1M2_PR
X$1135 PRDATA[7] VIA_L1M1_PR_MR
X$1136 PRDATA[5] VIA_M1M2_PR
X$1137 PRDATA[5] VIA_L1M1_PR_MR
X$1138
+ PRDATA[10]|PRDATA[12]|PRDATA[13]|PRDATA[15]|PRDATA[16]|PRDATA[17]|PRDATA[18]|PRDATA[19]|PRDATA[21]|PRDATA[23]|PRDATA[27]|PRDATA[28]|PRDATA[29]|PRDATA[31]|PRDATA[9]|PSLVERR
+ VIA_via5_6_1600_1600_1_1_1600_1600
X$1139
+ PRDATA[10]|PRDATA[12]|PRDATA[13]|PRDATA[15]|PRDATA[16]|PRDATA[17]|PRDATA[18]|PRDATA[19]|PRDATA[21]|PRDATA[23]|PRDATA[27]|PRDATA[28]|PRDATA[29]|PRDATA[31]|PRDATA[9]|PSLVERR
+ VIA_via5_6_1600_1600_1_1_1600_1600
X$1140
+ PRDATA[10]|PRDATA[12]|PRDATA[13]|PRDATA[15]|PRDATA[16]|PRDATA[17]|PRDATA[18]|PRDATA[19]|PRDATA[21]|PRDATA[23]|PRDATA[27]|PRDATA[28]|PRDATA[29]|PRDATA[31]|PRDATA[9]|PSLVERR
+ VIA_via5_6_1600_1600_1_1_1600_1600
X$1141
+ PRDATA[10]|PRDATA[12]|PRDATA[13]|PRDATA[15]|PRDATA[16]|PRDATA[17]|PRDATA[18]|PRDATA[19]|PRDATA[21]|PRDATA[23]|PRDATA[27]|PRDATA[28]|PRDATA[29]|PRDATA[31]|PRDATA[9]|PSLVERR
+ VIA_via5_6_1600_1600_1_1_1600_1600
X$1142
+ PRDATA[10]|PRDATA[12]|PRDATA[13]|PRDATA[15]|PRDATA[16]|PRDATA[17]|PRDATA[18]|PRDATA[19]|PRDATA[21]|PRDATA[23]|PRDATA[27]|PRDATA[28]|PRDATA[29]|PRDATA[31]|PRDATA[9]|PSLVERR
+ VIA_via2_3_1600_480_1_5_320_320
X$1143
+ PRDATA[10]|PRDATA[12]|PRDATA[13]|PRDATA[15]|PRDATA[16]|PRDATA[17]|PRDATA[18]|PRDATA[19]|PRDATA[21]|PRDATA[23]|PRDATA[27]|PRDATA[28]|PRDATA[29]|PRDATA[31]|PRDATA[9]|PSLVERR
+ VIA_via2_3_1600_480_1_5_320_320
X$1144
+ PRDATA[10]|PRDATA[12]|PRDATA[13]|PRDATA[15]|PRDATA[16]|PRDATA[17]|PRDATA[18]|PRDATA[19]|PRDATA[21]|PRDATA[23]|PRDATA[27]|PRDATA[28]|PRDATA[29]|PRDATA[31]|PRDATA[9]|PSLVERR
+ VIA_via3_4_1600_480_1_4_400_400
X$1145
+ PRDATA[10]|PRDATA[12]|PRDATA[13]|PRDATA[15]|PRDATA[16]|PRDATA[17]|PRDATA[18]|PRDATA[19]|PRDATA[21]|PRDATA[23]|PRDATA[27]|PRDATA[28]|PRDATA[29]|PRDATA[31]|PRDATA[9]|PSLVERR
+ VIA_via4_5_1600_480_1_4_400_400
X$1146
+ PRDATA[10]|PRDATA[12]|PRDATA[13]|PRDATA[15]|PRDATA[16]|PRDATA[17]|PRDATA[18]|PRDATA[19]|PRDATA[21]|PRDATA[23]|PRDATA[27]|PRDATA[28]|PRDATA[29]|PRDATA[31]|PRDATA[9]|PSLVERR
+ VIA_via3_4_1600_480_1_4_400_400
X$1147
+ PRDATA[10]|PRDATA[12]|PRDATA[13]|PRDATA[15]|PRDATA[16]|PRDATA[17]|PRDATA[18]|PRDATA[19]|PRDATA[21]|PRDATA[23]|PRDATA[27]|PRDATA[28]|PRDATA[29]|PRDATA[31]|PRDATA[9]|PSLVERR
+ VIA_via4_5_1600_480_1_4_400_400
X$1148
+ PRDATA[10]|PRDATA[12]|PRDATA[13]|PRDATA[15]|PRDATA[16]|PRDATA[17]|PRDATA[18]|PRDATA[19]|PRDATA[21]|PRDATA[23]|PRDATA[27]|PRDATA[28]|PRDATA[29]|PRDATA[31]|PRDATA[9]|PSLVERR
+ VIA_via2_3_1600_480_1_5_320_320
X$1149
+ PRDATA[10]|PRDATA[12]|PRDATA[13]|PRDATA[15]|PRDATA[16]|PRDATA[17]|PRDATA[18]|PRDATA[19]|PRDATA[21]|PRDATA[23]|PRDATA[27]|PRDATA[28]|PRDATA[29]|PRDATA[31]|PRDATA[9]|PSLVERR
+ VIA_via2_3_1600_480_1_5_320_320
X$1150
+ PRDATA[10]|PRDATA[12]|PRDATA[13]|PRDATA[15]|PRDATA[16]|PRDATA[17]|PRDATA[18]|PRDATA[19]|PRDATA[21]|PRDATA[23]|PRDATA[27]|PRDATA[28]|PRDATA[29]|PRDATA[31]|PRDATA[9]|PSLVERR
+ VIA_via3_4_1600_480_1_4_400_400
X$1151
+ PRDATA[10]|PRDATA[12]|PRDATA[13]|PRDATA[15]|PRDATA[16]|PRDATA[17]|PRDATA[18]|PRDATA[19]|PRDATA[21]|PRDATA[23]|PRDATA[27]|PRDATA[28]|PRDATA[29]|PRDATA[31]|PRDATA[9]|PSLVERR
+ VIA_via4_5_1600_480_1_4_400_400
X$1152
+ PRDATA[10]|PRDATA[12]|PRDATA[13]|PRDATA[15]|PRDATA[16]|PRDATA[17]|PRDATA[18]|PRDATA[19]|PRDATA[21]|PRDATA[23]|PRDATA[27]|PRDATA[28]|PRDATA[29]|PRDATA[31]|PRDATA[9]|PSLVERR
+ VIA_via3_4_1600_480_1_4_400_400
X$1153
+ PRDATA[10]|PRDATA[12]|PRDATA[13]|PRDATA[15]|PRDATA[16]|PRDATA[17]|PRDATA[18]|PRDATA[19]|PRDATA[21]|PRDATA[23]|PRDATA[27]|PRDATA[28]|PRDATA[29]|PRDATA[31]|PRDATA[9]|PSLVERR
+ VIA_via4_5_1600_480_1_4_400_400
X$1154
+ PRDATA[10]|PRDATA[12]|PRDATA[13]|PRDATA[15]|PRDATA[16]|PRDATA[17]|PRDATA[18]|PRDATA[19]|PRDATA[21]|PRDATA[23]|PRDATA[27]|PRDATA[28]|PRDATA[29]|PRDATA[31]|PRDATA[9]|PSLVERR
+ VIA_M2M3_PR
X$1155
+ PRDATA[10]|PRDATA[12]|PRDATA[13]|PRDATA[15]|PRDATA[16]|PRDATA[17]|PRDATA[18]|PRDATA[19]|PRDATA[21]|PRDATA[23]|PRDATA[27]|PRDATA[28]|PRDATA[29]|PRDATA[31]|PRDATA[9]|PSLVERR
+ VIA_M2M3_PR
X$1156
+ PRDATA[10]|PRDATA[12]|PRDATA[13]|PRDATA[15]|PRDATA[16]|PRDATA[17]|PRDATA[18]|PRDATA[19]|PRDATA[21]|PRDATA[23]|PRDATA[27]|PRDATA[28]|PRDATA[29]|PRDATA[31]|PRDATA[9]|PSLVERR
+ VIA_M2M3_PR
X$1157
+ PRDATA[10]|PRDATA[12]|PRDATA[13]|PRDATA[15]|PRDATA[16]|PRDATA[17]|PRDATA[18]|PRDATA[19]|PRDATA[21]|PRDATA[23]|PRDATA[27]|PRDATA[28]|PRDATA[29]|PRDATA[31]|PRDATA[9]|PSLVERR
+ VIA_M2M3_PR
X$1158
+ PRDATA[10]|PRDATA[12]|PRDATA[13]|PRDATA[15]|PRDATA[16]|PRDATA[17]|PRDATA[18]|PRDATA[19]|PRDATA[21]|PRDATA[23]|PRDATA[27]|PRDATA[28]|PRDATA[29]|PRDATA[31]|PRDATA[9]|PSLVERR
+ VIA_M2M3_PR
X$1159
+ PRDATA[10]|PRDATA[12]|PRDATA[13]|PRDATA[15]|PRDATA[16]|PRDATA[17]|PRDATA[18]|PRDATA[19]|PRDATA[21]|PRDATA[23]|PRDATA[27]|PRDATA[28]|PRDATA[29]|PRDATA[31]|PRDATA[9]|PSLVERR
+ VIA_M2M3_PR
X$1160
+ PRDATA[10]|PRDATA[12]|PRDATA[13]|PRDATA[15]|PRDATA[16]|PRDATA[17]|PRDATA[18]|PRDATA[19]|PRDATA[21]|PRDATA[23]|PRDATA[27]|PRDATA[28]|PRDATA[29]|PRDATA[31]|PRDATA[9]|PSLVERR
+ VIA_M2M3_PR
X$1161
+ PRDATA[10]|PRDATA[12]|PRDATA[13]|PRDATA[15]|PRDATA[16]|PRDATA[17]|PRDATA[18]|PRDATA[19]|PRDATA[21]|PRDATA[23]|PRDATA[27]|PRDATA[28]|PRDATA[29]|PRDATA[31]|PRDATA[9]|PSLVERR
+ VIA_M2M3_PR
X$1162
+ PRDATA[10]|PRDATA[12]|PRDATA[13]|PRDATA[15]|PRDATA[16]|PRDATA[17]|PRDATA[18]|PRDATA[19]|PRDATA[21]|PRDATA[23]|PRDATA[27]|PRDATA[28]|PRDATA[29]|PRDATA[31]|PRDATA[9]|PSLVERR
+ VIA_M2M3_PR
X$1163
+ PRDATA[10]|PRDATA[12]|PRDATA[13]|PRDATA[15]|PRDATA[16]|PRDATA[17]|PRDATA[18]|PRDATA[19]|PRDATA[21]|PRDATA[23]|PRDATA[27]|PRDATA[28]|PRDATA[29]|PRDATA[31]|PRDATA[9]|PSLVERR
+ VIA_M2M3_PR
X$1164
+ PRDATA[10]|PRDATA[12]|PRDATA[13]|PRDATA[15]|PRDATA[16]|PRDATA[17]|PRDATA[18]|PRDATA[19]|PRDATA[21]|PRDATA[23]|PRDATA[27]|PRDATA[28]|PRDATA[29]|PRDATA[31]|PRDATA[9]|PSLVERR
+ VIA_M2M3_PR
X$1165
+ PRDATA[10]|PRDATA[12]|PRDATA[13]|PRDATA[15]|PRDATA[16]|PRDATA[17]|PRDATA[18]|PRDATA[19]|PRDATA[21]|PRDATA[23]|PRDATA[27]|PRDATA[28]|PRDATA[29]|PRDATA[31]|PRDATA[9]|PSLVERR
+ VIA_M2M3_PR
X$1166
+ PRDATA[10]|PRDATA[12]|PRDATA[13]|PRDATA[15]|PRDATA[16]|PRDATA[17]|PRDATA[18]|PRDATA[19]|PRDATA[21]|PRDATA[23]|PRDATA[27]|PRDATA[28]|PRDATA[29]|PRDATA[31]|PRDATA[9]|PSLVERR
+ VIA_M2M3_PR
X$1167
+ PRDATA[10]|PRDATA[12]|PRDATA[13]|PRDATA[15]|PRDATA[16]|PRDATA[17]|PRDATA[18]|PRDATA[19]|PRDATA[21]|PRDATA[23]|PRDATA[27]|PRDATA[28]|PRDATA[29]|PRDATA[31]|PRDATA[9]|PSLVERR
+ VIA_M2M3_PR
X$1168
+ PRDATA[10]|PRDATA[12]|PRDATA[13]|PRDATA[15]|PRDATA[16]|PRDATA[17]|PRDATA[18]|PRDATA[19]|PRDATA[21]|PRDATA[23]|PRDATA[27]|PRDATA[28]|PRDATA[29]|PRDATA[31]|PRDATA[9]|PSLVERR
+ VIA_M2M3_PR
X$1169
+ PRDATA[10]|PRDATA[12]|PRDATA[13]|PRDATA[15]|PRDATA[16]|PRDATA[17]|PRDATA[18]|PRDATA[19]|PRDATA[21]|PRDATA[23]|PRDATA[27]|PRDATA[28]|PRDATA[29]|PRDATA[31]|PRDATA[9]|PSLVERR
+ VIA_M1M2_PR
X$1170
+ PRDATA[10]|PRDATA[12]|PRDATA[13]|PRDATA[15]|PRDATA[16]|PRDATA[17]|PRDATA[18]|PRDATA[19]|PRDATA[21]|PRDATA[23]|PRDATA[27]|PRDATA[28]|PRDATA[29]|PRDATA[31]|PRDATA[9]|PSLVERR
+ VIA_M2M3_PR
X$1171
+ PRDATA[10]|PRDATA[12]|PRDATA[13]|PRDATA[15]|PRDATA[16]|PRDATA[17]|PRDATA[18]|PRDATA[19]|PRDATA[21]|PRDATA[23]|PRDATA[27]|PRDATA[28]|PRDATA[29]|PRDATA[31]|PRDATA[9]|PSLVERR
+ VIA_via2_3_1600_480_1_5_320_320
X$1172
+ PRDATA[10]|PRDATA[12]|PRDATA[13]|PRDATA[15]|PRDATA[16]|PRDATA[17]|PRDATA[18]|PRDATA[19]|PRDATA[21]|PRDATA[23]|PRDATA[27]|PRDATA[28]|PRDATA[29]|PRDATA[31]|PRDATA[9]|PSLVERR
+ VIA_via2_3_1600_480_1_5_320_320
X$1173
+ PRDATA[10]|PRDATA[12]|PRDATA[13]|PRDATA[15]|PRDATA[16]|PRDATA[17]|PRDATA[18]|PRDATA[19]|PRDATA[21]|PRDATA[23]|PRDATA[27]|PRDATA[28]|PRDATA[29]|PRDATA[31]|PRDATA[9]|PSLVERR
+ VIA_via3_4_1600_480_1_4_400_400
X$1174
+ PRDATA[10]|PRDATA[12]|PRDATA[13]|PRDATA[15]|PRDATA[16]|PRDATA[17]|PRDATA[18]|PRDATA[19]|PRDATA[21]|PRDATA[23]|PRDATA[27]|PRDATA[28]|PRDATA[29]|PRDATA[31]|PRDATA[9]|PSLVERR
+ VIA_via4_5_1600_480_1_4_400_400
X$1175
+ PRDATA[10]|PRDATA[12]|PRDATA[13]|PRDATA[15]|PRDATA[16]|PRDATA[17]|PRDATA[18]|PRDATA[19]|PRDATA[21]|PRDATA[23]|PRDATA[27]|PRDATA[28]|PRDATA[29]|PRDATA[31]|PRDATA[9]|PSLVERR
+ VIA_via3_4_1600_480_1_4_400_400
X$1176
+ PRDATA[10]|PRDATA[12]|PRDATA[13]|PRDATA[15]|PRDATA[16]|PRDATA[17]|PRDATA[18]|PRDATA[19]|PRDATA[21]|PRDATA[23]|PRDATA[27]|PRDATA[28]|PRDATA[29]|PRDATA[31]|PRDATA[9]|PSLVERR
+ VIA_via4_5_1600_480_1_4_400_400
X$1177
+ PRDATA[10]|PRDATA[12]|PRDATA[13]|PRDATA[15]|PRDATA[16]|PRDATA[17]|PRDATA[18]|PRDATA[19]|PRDATA[21]|PRDATA[23]|PRDATA[27]|PRDATA[28]|PRDATA[29]|PRDATA[31]|PRDATA[9]|PSLVERR
+ VIA_via2_3_1600_480_1_5_320_320
X$1178
+ PRDATA[10]|PRDATA[12]|PRDATA[13]|PRDATA[15]|PRDATA[16]|PRDATA[17]|PRDATA[18]|PRDATA[19]|PRDATA[21]|PRDATA[23]|PRDATA[27]|PRDATA[28]|PRDATA[29]|PRDATA[31]|PRDATA[9]|PSLVERR
+ VIA_via2_3_1600_480_1_5_320_320
X$1179
+ PRDATA[10]|PRDATA[12]|PRDATA[13]|PRDATA[15]|PRDATA[16]|PRDATA[17]|PRDATA[18]|PRDATA[19]|PRDATA[21]|PRDATA[23]|PRDATA[27]|PRDATA[28]|PRDATA[29]|PRDATA[31]|PRDATA[9]|PSLVERR
+ VIA_via3_4_1600_480_1_4_400_400
X$1180
+ PRDATA[10]|PRDATA[12]|PRDATA[13]|PRDATA[15]|PRDATA[16]|PRDATA[17]|PRDATA[18]|PRDATA[19]|PRDATA[21]|PRDATA[23]|PRDATA[27]|PRDATA[28]|PRDATA[29]|PRDATA[31]|PRDATA[9]|PSLVERR
+ VIA_via4_5_1600_480_1_4_400_400
X$1181
+ PRDATA[10]|PRDATA[12]|PRDATA[13]|PRDATA[15]|PRDATA[16]|PRDATA[17]|PRDATA[18]|PRDATA[19]|PRDATA[21]|PRDATA[23]|PRDATA[27]|PRDATA[28]|PRDATA[29]|PRDATA[31]|PRDATA[9]|PSLVERR
+ VIA_via3_4_1600_480_1_4_400_400
X$1182
+ PRDATA[10]|PRDATA[12]|PRDATA[13]|PRDATA[15]|PRDATA[16]|PRDATA[17]|PRDATA[18]|PRDATA[19]|PRDATA[21]|PRDATA[23]|PRDATA[27]|PRDATA[28]|PRDATA[29]|PRDATA[31]|PRDATA[9]|PSLVERR
+ VIA_via4_5_1600_480_1_4_400_400
X$1183
+ PRDATA[10]|PRDATA[12]|PRDATA[13]|PRDATA[15]|PRDATA[16]|PRDATA[17]|PRDATA[18]|PRDATA[19]|PRDATA[21]|PRDATA[23]|PRDATA[27]|PRDATA[28]|PRDATA[29]|PRDATA[31]|PRDATA[9]|PSLVERR
+ VIA_via2_3_1600_480_1_5_320_320
X$1184
+ PRDATA[10]|PRDATA[12]|PRDATA[13]|PRDATA[15]|PRDATA[16]|PRDATA[17]|PRDATA[18]|PRDATA[19]|PRDATA[21]|PRDATA[23]|PRDATA[27]|PRDATA[28]|PRDATA[29]|PRDATA[31]|PRDATA[9]|PSLVERR
+ VIA_via3_4_1600_480_1_4_400_400
X$1185
+ PRDATA[10]|PRDATA[12]|PRDATA[13]|PRDATA[15]|PRDATA[16]|PRDATA[17]|PRDATA[18]|PRDATA[19]|PRDATA[21]|PRDATA[23]|PRDATA[27]|PRDATA[28]|PRDATA[29]|PRDATA[31]|PRDATA[9]|PSLVERR
+ VIA_via4_5_1600_480_1_4_400_400
X$1186
+ PRDATA[10]|PRDATA[12]|PRDATA[13]|PRDATA[15]|PRDATA[16]|PRDATA[17]|PRDATA[18]|PRDATA[19]|PRDATA[21]|PRDATA[23]|PRDATA[27]|PRDATA[28]|PRDATA[29]|PRDATA[31]|PRDATA[9]|PSLVERR
+ VIA_via2_3_1600_480_1_5_320_320
X$1187
+ PRDATA[10]|PRDATA[12]|PRDATA[13]|PRDATA[15]|PRDATA[16]|PRDATA[17]|PRDATA[18]|PRDATA[19]|PRDATA[21]|PRDATA[23]|PRDATA[27]|PRDATA[28]|PRDATA[29]|PRDATA[31]|PRDATA[9]|PSLVERR
+ VIA_via3_4_1600_480_1_4_400_400
X$1188
+ PRDATA[10]|PRDATA[12]|PRDATA[13]|PRDATA[15]|PRDATA[16]|PRDATA[17]|PRDATA[18]|PRDATA[19]|PRDATA[21]|PRDATA[23]|PRDATA[27]|PRDATA[28]|PRDATA[29]|PRDATA[31]|PRDATA[9]|PSLVERR
+ VIA_via4_5_1600_480_1_4_400_400
X$1189
+ PRDATA[10]|PRDATA[12]|PRDATA[13]|PRDATA[15]|PRDATA[16]|PRDATA[17]|PRDATA[18]|PRDATA[19]|PRDATA[21]|PRDATA[23]|PRDATA[27]|PRDATA[28]|PRDATA[29]|PRDATA[31]|PRDATA[9]|PSLVERR
+ VIA_via2_3_1600_480_1_5_320_320
X$1190
+ PRDATA[10]|PRDATA[12]|PRDATA[13]|PRDATA[15]|PRDATA[16]|PRDATA[17]|PRDATA[18]|PRDATA[19]|PRDATA[21]|PRDATA[23]|PRDATA[27]|PRDATA[28]|PRDATA[29]|PRDATA[31]|PRDATA[9]|PSLVERR
+ VIA_via2_3_1600_480_1_5_320_320
X$1191
+ PRDATA[10]|PRDATA[12]|PRDATA[13]|PRDATA[15]|PRDATA[16]|PRDATA[17]|PRDATA[18]|PRDATA[19]|PRDATA[21]|PRDATA[23]|PRDATA[27]|PRDATA[28]|PRDATA[29]|PRDATA[31]|PRDATA[9]|PSLVERR
+ VIA_via3_4_1600_480_1_4_400_400
X$1192
+ PRDATA[10]|PRDATA[12]|PRDATA[13]|PRDATA[15]|PRDATA[16]|PRDATA[17]|PRDATA[18]|PRDATA[19]|PRDATA[21]|PRDATA[23]|PRDATA[27]|PRDATA[28]|PRDATA[29]|PRDATA[31]|PRDATA[9]|PSLVERR
+ VIA_via4_5_1600_480_1_4_400_400
X$1193
+ PRDATA[10]|PRDATA[12]|PRDATA[13]|PRDATA[15]|PRDATA[16]|PRDATA[17]|PRDATA[18]|PRDATA[19]|PRDATA[21]|PRDATA[23]|PRDATA[27]|PRDATA[28]|PRDATA[29]|PRDATA[31]|PRDATA[9]|PSLVERR
+ VIA_via3_4_1600_480_1_4_400_400
X$1194
+ PRDATA[10]|PRDATA[12]|PRDATA[13]|PRDATA[15]|PRDATA[16]|PRDATA[17]|PRDATA[18]|PRDATA[19]|PRDATA[21]|PRDATA[23]|PRDATA[27]|PRDATA[28]|PRDATA[29]|PRDATA[31]|PRDATA[9]|PSLVERR
+ VIA_via4_5_1600_480_1_4_400_400
X$1195
+ PRDATA[10]|PRDATA[12]|PRDATA[13]|PRDATA[15]|PRDATA[16]|PRDATA[17]|PRDATA[18]|PRDATA[19]|PRDATA[21]|PRDATA[23]|PRDATA[27]|PRDATA[28]|PRDATA[29]|PRDATA[31]|PRDATA[9]|PSLVERR
+ VIA_via2_3_1600_480_1_5_320_320
X$1196
+ PRDATA[10]|PRDATA[12]|PRDATA[13]|PRDATA[15]|PRDATA[16]|PRDATA[17]|PRDATA[18]|PRDATA[19]|PRDATA[21]|PRDATA[23]|PRDATA[27]|PRDATA[28]|PRDATA[29]|PRDATA[31]|PRDATA[9]|PSLVERR
+ VIA_via3_4_1600_480_1_4_400_400
X$1197
+ PRDATA[10]|PRDATA[12]|PRDATA[13]|PRDATA[15]|PRDATA[16]|PRDATA[17]|PRDATA[18]|PRDATA[19]|PRDATA[21]|PRDATA[23]|PRDATA[27]|PRDATA[28]|PRDATA[29]|PRDATA[31]|PRDATA[9]|PSLVERR
+ VIA_via4_5_1600_480_1_4_400_400
X$1198
+ PRDATA[10]|PRDATA[12]|PRDATA[13]|PRDATA[15]|PRDATA[16]|PRDATA[17]|PRDATA[18]|PRDATA[19]|PRDATA[21]|PRDATA[23]|PRDATA[27]|PRDATA[28]|PRDATA[29]|PRDATA[31]|PRDATA[9]|PSLVERR
+ VIA_via2_3_1600_480_1_5_320_320
X$1199
+ PRDATA[10]|PRDATA[12]|PRDATA[13]|PRDATA[15]|PRDATA[16]|PRDATA[17]|PRDATA[18]|PRDATA[19]|PRDATA[21]|PRDATA[23]|PRDATA[27]|PRDATA[28]|PRDATA[29]|PRDATA[31]|PRDATA[9]|PSLVERR
+ VIA_via3_4_1600_480_1_4_400_400
X$1200
+ PRDATA[10]|PRDATA[12]|PRDATA[13]|PRDATA[15]|PRDATA[16]|PRDATA[17]|PRDATA[18]|PRDATA[19]|PRDATA[21]|PRDATA[23]|PRDATA[27]|PRDATA[28]|PRDATA[29]|PRDATA[31]|PRDATA[9]|PSLVERR
+ VIA_via4_5_1600_480_1_4_400_400
X$1201
+ PRDATA[10]|PRDATA[12]|PRDATA[13]|PRDATA[15]|PRDATA[16]|PRDATA[17]|PRDATA[18]|PRDATA[19]|PRDATA[21]|PRDATA[23]|PRDATA[27]|PRDATA[28]|PRDATA[29]|PRDATA[31]|PRDATA[9]|PSLVERR
+ VIA_via2_3_1600_480_1_5_320_320
X$1202
+ PRDATA[10]|PRDATA[12]|PRDATA[13]|PRDATA[15]|PRDATA[16]|PRDATA[17]|PRDATA[18]|PRDATA[19]|PRDATA[21]|PRDATA[23]|PRDATA[27]|PRDATA[28]|PRDATA[29]|PRDATA[31]|PRDATA[9]|PSLVERR
+ VIA_via2_3_1600_480_1_5_320_320
X$1203
+ PRDATA[10]|PRDATA[12]|PRDATA[13]|PRDATA[15]|PRDATA[16]|PRDATA[17]|PRDATA[18]|PRDATA[19]|PRDATA[21]|PRDATA[23]|PRDATA[27]|PRDATA[28]|PRDATA[29]|PRDATA[31]|PRDATA[9]|PSLVERR
+ VIA_via3_4_1600_480_1_4_400_400
X$1204
+ PRDATA[10]|PRDATA[12]|PRDATA[13]|PRDATA[15]|PRDATA[16]|PRDATA[17]|PRDATA[18]|PRDATA[19]|PRDATA[21]|PRDATA[23]|PRDATA[27]|PRDATA[28]|PRDATA[29]|PRDATA[31]|PRDATA[9]|PSLVERR
+ VIA_via4_5_1600_480_1_4_400_400
X$1205
+ PRDATA[10]|PRDATA[12]|PRDATA[13]|PRDATA[15]|PRDATA[16]|PRDATA[17]|PRDATA[18]|PRDATA[19]|PRDATA[21]|PRDATA[23]|PRDATA[27]|PRDATA[28]|PRDATA[29]|PRDATA[31]|PRDATA[9]|PSLVERR
+ VIA_via3_4_1600_480_1_4_400_400
X$1206
+ PRDATA[10]|PRDATA[12]|PRDATA[13]|PRDATA[15]|PRDATA[16]|PRDATA[17]|PRDATA[18]|PRDATA[19]|PRDATA[21]|PRDATA[23]|PRDATA[27]|PRDATA[28]|PRDATA[29]|PRDATA[31]|PRDATA[9]|PSLVERR
+ VIA_via4_5_1600_480_1_4_400_400
X$1207
+ PRDATA[10]|PRDATA[12]|PRDATA[13]|PRDATA[15]|PRDATA[16]|PRDATA[17]|PRDATA[18]|PRDATA[19]|PRDATA[21]|PRDATA[23]|PRDATA[27]|PRDATA[28]|PRDATA[29]|PRDATA[31]|PRDATA[9]|PSLVERR
+ VIA_L1M1_PR_MR
X$1208
+ PRDATA[10]|PRDATA[12]|PRDATA[13]|PRDATA[15]|PRDATA[16]|PRDATA[17]|PRDATA[18]|PRDATA[19]|PRDATA[21]|PRDATA[23]|PRDATA[27]|PRDATA[28]|PRDATA[29]|PRDATA[31]|PRDATA[9]|PSLVERR
+ VIA_via2_3_1600_480_1_5_320_320
X$1209
+ PRDATA[10]|PRDATA[12]|PRDATA[13]|PRDATA[15]|PRDATA[16]|PRDATA[17]|PRDATA[18]|PRDATA[19]|PRDATA[21]|PRDATA[23]|PRDATA[27]|PRDATA[28]|PRDATA[29]|PRDATA[31]|PRDATA[9]|PSLVERR
+ VIA_via2_3_1600_480_1_5_320_320
X$1210
+ PRDATA[10]|PRDATA[12]|PRDATA[13]|PRDATA[15]|PRDATA[16]|PRDATA[17]|PRDATA[18]|PRDATA[19]|PRDATA[21]|PRDATA[23]|PRDATA[27]|PRDATA[28]|PRDATA[29]|PRDATA[31]|PRDATA[9]|PSLVERR
+ VIA_via3_4_1600_480_1_4_400_400
X$1211
+ PRDATA[10]|PRDATA[12]|PRDATA[13]|PRDATA[15]|PRDATA[16]|PRDATA[17]|PRDATA[18]|PRDATA[19]|PRDATA[21]|PRDATA[23]|PRDATA[27]|PRDATA[28]|PRDATA[29]|PRDATA[31]|PRDATA[9]|PSLVERR
+ VIA_via4_5_1600_480_1_4_400_400
X$1212
+ PRDATA[10]|PRDATA[12]|PRDATA[13]|PRDATA[15]|PRDATA[16]|PRDATA[17]|PRDATA[18]|PRDATA[19]|PRDATA[21]|PRDATA[23]|PRDATA[27]|PRDATA[28]|PRDATA[29]|PRDATA[31]|PRDATA[9]|PSLVERR
+ VIA_via3_4_1600_480_1_4_400_400
X$1213
+ PRDATA[10]|PRDATA[12]|PRDATA[13]|PRDATA[15]|PRDATA[16]|PRDATA[17]|PRDATA[18]|PRDATA[19]|PRDATA[21]|PRDATA[23]|PRDATA[27]|PRDATA[28]|PRDATA[29]|PRDATA[31]|PRDATA[9]|PSLVERR
+ VIA_via4_5_1600_480_1_4_400_400
X$1214
+ PRDATA[10]|PRDATA[12]|PRDATA[13]|PRDATA[15]|PRDATA[16]|PRDATA[17]|PRDATA[18]|PRDATA[19]|PRDATA[21]|PRDATA[23]|PRDATA[27]|PRDATA[28]|PRDATA[29]|PRDATA[31]|PRDATA[9]|PSLVERR
+ VIA_via2_3_1600_480_1_5_320_320
X$1215
+ PRDATA[10]|PRDATA[12]|PRDATA[13]|PRDATA[15]|PRDATA[16]|PRDATA[17]|PRDATA[18]|PRDATA[19]|PRDATA[21]|PRDATA[23]|PRDATA[27]|PRDATA[28]|PRDATA[29]|PRDATA[31]|PRDATA[9]|PSLVERR
+ VIA_via2_3_1600_480_1_5_320_320
X$1216
+ PRDATA[10]|PRDATA[12]|PRDATA[13]|PRDATA[15]|PRDATA[16]|PRDATA[17]|PRDATA[18]|PRDATA[19]|PRDATA[21]|PRDATA[23]|PRDATA[27]|PRDATA[28]|PRDATA[29]|PRDATA[31]|PRDATA[9]|PSLVERR
+ VIA_via3_4_1600_480_1_4_400_400
X$1217
+ PRDATA[10]|PRDATA[12]|PRDATA[13]|PRDATA[15]|PRDATA[16]|PRDATA[17]|PRDATA[18]|PRDATA[19]|PRDATA[21]|PRDATA[23]|PRDATA[27]|PRDATA[28]|PRDATA[29]|PRDATA[31]|PRDATA[9]|PSLVERR
+ VIA_via4_5_1600_480_1_4_400_400
X$1218
+ PRDATA[10]|PRDATA[12]|PRDATA[13]|PRDATA[15]|PRDATA[16]|PRDATA[17]|PRDATA[18]|PRDATA[19]|PRDATA[21]|PRDATA[23]|PRDATA[27]|PRDATA[28]|PRDATA[29]|PRDATA[31]|PRDATA[9]|PSLVERR
+ VIA_via3_4_1600_480_1_4_400_400
X$1219
+ PRDATA[10]|PRDATA[12]|PRDATA[13]|PRDATA[15]|PRDATA[16]|PRDATA[17]|PRDATA[18]|PRDATA[19]|PRDATA[21]|PRDATA[23]|PRDATA[27]|PRDATA[28]|PRDATA[29]|PRDATA[31]|PRDATA[9]|PSLVERR
+ VIA_via4_5_1600_480_1_4_400_400
.ENDS apb_gpio

.SUBCKT sky130_fd_sc_hd__nand3_1 VPB Y VPWR VGND C B A
M$1 VPWR C Y VPB sky130_fd_pr__pfet_01v8_hvt L=0.15 W=1 AS=0.26 AD=0.135
+ PS=2.52 PD=1.27
M$2 Y B VPWR VPB sky130_fd_pr__pfet_01v8_hvt L=0.15 W=1 AS=0.135 AD=0.165
+ PS=1.27 PD=1.33
M$3 VPWR A Y VPB sky130_fd_pr__pfet_01v8_hvt L=0.15 W=1 AS=0.165 AD=0.26
+ PS=1.33 PD=2.52
M$4 VGND C \$10 VGND sky130_fd_pr__nfet_01v8 L=0.15 W=0.65 AS=0.169 AD=0.08775
+ PS=1.82 PD=0.92
M$5 \$10 B \$9 VGND sky130_fd_pr__nfet_01v8 L=0.15 W=0.65 AS=0.08775 AD=0.10725
+ PS=0.92 PD=0.98
M$6 \$9 A Y VGND sky130_fd_pr__nfet_01v8 L=0.15 W=0.65 AS=0.10725 AD=0.169
+ PS=0.98 PD=1.82
.ENDS sky130_fd_sc_hd__nand3_1

.SUBCKT sky130_fd_sc_hd__nor2b_1 VPB VGND Y B_N A VPWR
M$1 \$4 B_N VPWR VPB sky130_fd_pr__pfet_01v8_hvt L=0.15 W=0.42 AS=0.1092
+ AD=0.1573 PS=1.36 PD=1.39
M$2 VPWR A \$9 VPB sky130_fd_pr__pfet_01v8_hvt L=0.15 W=1 AS=0.1573 AD=0.105
+ PS=1.39 PD=1.21
M$3 \$9 \$4 Y VPB sky130_fd_pr__pfet_01v8_hvt L=0.15 W=1 AS=0.105 AD=0.26
+ PS=1.21 PD=2.52
M$4 \$4 B_N VGND VGND sky130_fd_pr__nfet_01v8 L=0.15 W=0.42 AS=0.1092
+ AD=0.10025 PS=1.36 PD=0.985
M$5 VGND A Y VGND sky130_fd_pr__nfet_01v8 L=0.15 W=0.65 AS=0.10025 AD=0.08775
+ PS=0.985 PD=0.92
M$6 Y \$4 VGND VGND sky130_fd_pr__nfet_01v8 L=0.15 W=0.65 AS=0.08775 AD=0.169
+ PS=0.92 PD=1.82
.ENDS sky130_fd_sc_hd__nor2b_1

.SUBCKT sky130_fd_sc_hd__nand2b_1 VPB Y B VPWR VGND A_N
M$1 \$2 A_N VPWR VPB sky130_fd_pr__pfet_01v8_hvt L=0.15 W=0.42 AS=0.1092
+ AD=0.14575 PS=1.36 PD=1.335
M$2 VPWR B Y VPB sky130_fd_pr__pfet_01v8_hvt L=0.15 W=1 AS=0.14575 AD=0.135
+ PS=1.335 PD=1.27
M$3 Y \$2 VPWR VPB sky130_fd_pr__pfet_01v8_hvt L=0.15 W=1 AS=0.135 AD=0.265
+ PS=1.27 PD=2.53
M$4 VGND A_N \$2 VGND sky130_fd_pr__nfet_01v8 L=0.15 W=0.42 AS=0.10025
+ AD=0.1092 PS=0.985 PD=1.36
M$5 VGND B \$9 VGND sky130_fd_pr__nfet_01v8 L=0.15 W=0.65 AS=0.10025 AD=0.08775
+ PS=0.985 PD=0.92
M$6 \$9 \$2 Y VGND sky130_fd_pr__nfet_01v8 L=0.15 W=0.65 AS=0.08775 AD=0.169
+ PS=0.92 PD=1.82
.ENDS sky130_fd_sc_hd__nand2b_1

.SUBCKT sky130_fd_sc_hd__and2_1 VPB A X VPWR B VGND
M$1 VPWR A \$5 VPB sky130_fd_pr__pfet_01v8_hvt L=0.15 W=0.42 AS=0.1176
+ AD=0.0567 PS=1.4 PD=0.69
M$2 VPWR B \$5 VPB sky130_fd_pr__pfet_01v8_hvt L=0.15 W=0.42 AS=0.16655
+ AD=0.0567 PS=1.39 PD=0.69
M$3 VPWR \$5 X VPB sky130_fd_pr__pfet_01v8_hvt L=0.15 W=1 AS=0.16655 AD=0.475
+ PS=1.39 PD=2.95
M$4 \$5 A \$9 VGND sky130_fd_pr__nfet_01v8 L=0.15 W=0.42 AS=0.1176 AD=0.0567
+ PS=1.4 PD=0.69
M$5 VGND B \$9 VGND sky130_fd_pr__nfet_01v8 L=0.15 W=0.42 AS=0.1118 AD=0.0567
+ PS=1.04 PD=0.69
M$6 VGND \$5 X VGND sky130_fd_pr__nfet_01v8 L=0.15 W=0.65 AS=0.1118 AD=0.182
+ PS=1.04 PD=1.86
.ENDS sky130_fd_sc_hd__and2_1

.SUBCKT sky130_fd_sc_hd__and2b_1 VPB X VGND VPWR B A_N
M$1 \$7 A_N VPWR VPB sky130_fd_pr__pfet_01v8_hvt L=0.15 W=0.42 AS=0.1092
+ AD=0.0714 PS=1.36 PD=0.76
M$2 VPWR \$7 \$3 VPB sky130_fd_pr__pfet_01v8_hvt L=0.15 W=0.42 AS=0.0714
+ AD=0.0609 PS=0.76 PD=0.71
M$3 VPWR B \$3 VPB sky130_fd_pr__pfet_01v8_hvt L=0.15 W=0.42 AS=0.2279
+ AD=0.0609 PS=1.74 PD=0.71
M$4 VPWR \$3 X VPB sky130_fd_pr__pfet_01v8_hvt L=0.15 W=1 AS=0.2279 AD=0.26
+ PS=1.74 PD=2.52
M$5 \$3 \$7 \$10 VGND sky130_fd_pr__nfet_01v8 L=0.15 W=0.42 AS=0.1092 AD=0.0504
+ PS=1.36 PD=0.66
M$6 \$10 B VGND VGND sky130_fd_pr__nfet_01v8 L=0.15 W=0.42 AS=0.0504 AD=0.1013
+ PS=0.66 PD=0.99
M$7 VGND \$3 X VGND sky130_fd_pr__nfet_01v8 L=0.15 W=0.65 AS=0.1013 AD=0.169
+ PS=0.99 PD=1.82
M$8 VGND A_N \$7 VGND sky130_fd_pr__nfet_01v8 L=0.15 W=0.42 AS=0.1092 AD=0.1092
+ PS=1.36 PD=1.36
.ENDS sky130_fd_sc_hd__and2b_1

.SUBCKT sky130_fd_sc_hd__conb_1 VPB HI|VPWR LO|VGND
.ENDS sky130_fd_sc_hd__conb_1

.SUBCKT sky130_fd_sc_hd__buf_4 VPB A VPWR VGND X
M$1 \$5 A VPWR VPB sky130_fd_pr__pfet_01v8_hvt L=0.15 W=1 AS=0.26 AD=0.135
+ PS=2.52 PD=1.27
M$2 VPWR \$5 X VPB sky130_fd_pr__pfet_01v8_hvt L=0.15 W=1 AS=0.135 AD=0.135
+ PS=1.27 PD=1.27
M$3 X \$5 VPWR VPB sky130_fd_pr__pfet_01v8_hvt L=0.15 W=1 AS=0.135 AD=0.135
+ PS=1.27 PD=1.27
M$4 VPWR \$5 X VPB sky130_fd_pr__pfet_01v8_hvt L=0.15 W=1 AS=0.135 AD=0.135
+ PS=1.27 PD=1.27
M$5 X \$5 VPWR VPB sky130_fd_pr__pfet_01v8_hvt L=0.15 W=1 AS=0.135 AD=0.26
+ PS=1.27 PD=2.52
M$6 \$5 A VGND VGND sky130_fd_pr__nfet_01v8 L=0.15 W=0.65 AS=0.169 AD=0.08775
+ PS=1.82 PD=0.92
M$7 VGND \$5 X VGND sky130_fd_pr__nfet_01v8 L=0.15 W=0.65 AS=0.08775 AD=0.08775
+ PS=0.92 PD=0.92
M$8 X \$5 VGND VGND sky130_fd_pr__nfet_01v8 L=0.15 W=0.65 AS=0.08775 AD=0.08775
+ PS=0.92 PD=0.92
M$9 VGND \$5 X VGND sky130_fd_pr__nfet_01v8 L=0.15 W=0.65 AS=0.08775 AD=0.08775
+ PS=0.92 PD=0.92
M$10 X \$5 VGND VGND sky130_fd_pr__nfet_01v8 L=0.15 W=0.65 AS=0.08775 AD=0.169
+ PS=0.92 PD=1.82
.ENDS sky130_fd_sc_hd__buf_4

.SUBCKT sky130_fd_sc_hd__a21oi_2 VPB VPWR A1 Y A2 VGND B1
M$1 \$4 A2 VPWR VPB sky130_fd_pr__pfet_01v8_hvt L=0.15 W=1 AS=0.28 AD=0.14
+ PS=2.56 PD=1.28
M$2 VPWR A1 \$4 VPB sky130_fd_pr__pfet_01v8_hvt L=0.15 W=1 AS=0.14 AD=0.14
+ PS=1.28 PD=1.28
M$3 \$4 A1 VPWR VPB sky130_fd_pr__pfet_01v8_hvt L=0.15 W=1 AS=0.14 AD=0.135
+ PS=1.28 PD=1.27
M$4 VPWR A2 \$4 VPB sky130_fd_pr__pfet_01v8_hvt L=0.15 W=1 AS=0.135 AD=0.135
+ PS=1.27 PD=1.27
M$5 \$4 B1 Y VPB sky130_fd_pr__pfet_01v8_hvt L=0.15 W=1 AS=0.135 AD=0.135
+ PS=1.27 PD=1.27
M$6 Y B1 \$4 VPB sky130_fd_pr__pfet_01v8_hvt L=0.15 W=1 AS=0.135 AD=0.36
+ PS=1.27 PD=2.72
M$7 VGND A2 \$10 VGND sky130_fd_pr__nfet_01v8 L=0.15 W=0.65 AS=0.18525
+ AD=0.089375 PS=1.87 PD=0.925
M$8 \$10 A1 Y VGND sky130_fd_pr__nfet_01v8 L=0.15 W=0.65 AS=0.089375 AD=0.091
+ PS=0.925 PD=0.93
M$9 Y A1 \$11 VGND sky130_fd_pr__nfet_01v8 L=0.15 W=0.65 AS=0.091 AD=0.06825
+ PS=0.93 PD=0.86
M$10 \$11 A2 VGND VGND sky130_fd_pr__nfet_01v8 L=0.15 W=0.65 AS=0.06825
+ AD=0.10725 PS=0.86 PD=0.98
M$11 VGND B1 Y VGND sky130_fd_pr__nfet_01v8 L=0.15 W=0.65 AS=0.10725 AD=0.08775
+ PS=0.98 PD=0.92
M$12 Y B1 VGND VGND sky130_fd_pr__nfet_01v8 L=0.15 W=0.65 AS=0.08775 AD=0.26
+ PS=0.92 PD=2.1
.ENDS sky130_fd_sc_hd__a21oi_2

.SUBCKT sky130_fd_sc_hd__a222oi_1 VGND Y C1 C2 B2 B1 A1 A2 VPWR VPB
M$1 \$14 B2 \$13 VPB sky130_fd_pr__pfet_01v8_hvt L=0.15 W=1 AS=0.26 AD=0.135
+ PS=2.52 PD=1.27
M$2 \$13 B1 \$14 VPB sky130_fd_pr__pfet_01v8_hvt L=0.15 W=1 AS=0.135 AD=0.135
+ PS=1.27 PD=1.27
M$3 \$14 A1 VPWR VPB sky130_fd_pr__pfet_01v8_hvt L=0.15 W=1 AS=0.135 AD=0.165
+ PS=1.27 PD=1.33
M$4 VPWR A2 \$14 VPB sky130_fd_pr__pfet_01v8_hvt L=0.15 W=1 AS=0.165 AD=0.26
+ PS=1.33 PD=2.52
M$5 Y C1 \$13 VPB sky130_fd_pr__pfet_01v8_hvt L=0.15 W=1 AS=0.26 AD=0.135
+ PS=2.52 PD=1.27
M$6 \$13 C2 Y VPB sky130_fd_pr__pfet_01v8_hvt L=0.15 W=1 AS=0.135 AD=0.26
+ PS=1.27 PD=2.52
M$7 Y C1 \$4 VGND sky130_fd_pr__nfet_01v8 L=0.15 W=0.64 AS=0.1664 AD=0.0672
+ PS=1.8 PD=0.85
M$8 \$4 C2 VGND VGND sky130_fd_pr__nfet_01v8 L=0.15 W=0.64 AS=0.0672 AD=0.2912
+ PS=0.85 PD=1.55
M$9 VGND B2 \$6 VGND sky130_fd_pr__nfet_01v8 L=0.15 W=0.64 AS=0.2912 AD=0.0672
+ PS=1.55 PD=0.85
M$10 \$6 B1 Y VGND sky130_fd_pr__nfet_01v8 L=0.15 W=0.64 AS=0.0672 AD=0.1056
+ PS=0.85 PD=0.97
M$11 Y A1 \$5 VGND sky130_fd_pr__nfet_01v8 L=0.15 W=0.64 AS=0.1056 AD=0.1056
+ PS=0.97 PD=0.97
M$12 \$5 A2 VGND VGND sky130_fd_pr__nfet_01v8 L=0.15 W=0.64 AS=0.1056 AD=0.1664
+ PS=0.97 PD=1.8
.ENDS sky130_fd_sc_hd__a222oi_1

.SUBCKT sky130_fd_sc_hd__nor4b_4 VGND A B C Y D_N VPWR VPB
M$1 \$12 C \$11 VPB sky130_fd_pr__pfet_01v8_hvt L=0.15 W=1 AS=0.26 AD=0.135
+ PS=2.52 PD=1.27
M$2 \$11 C \$12 VPB sky130_fd_pr__pfet_01v8_hvt L=0.15 W=1 AS=0.135 AD=0.135
+ PS=1.27 PD=1.27
M$3 \$12 C \$11 VPB sky130_fd_pr__pfet_01v8_hvt L=0.15 W=1 AS=0.135 AD=0.135
+ PS=1.27 PD=1.27
M$4 \$11 C \$12 VPB sky130_fd_pr__pfet_01v8_hvt L=0.15 W=1 AS=0.135 AD=0.135
+ PS=1.27 PD=1.27
M$5 \$12 \$5 Y VPB sky130_fd_pr__pfet_01v8_hvt L=0.15 W=1 AS=0.135 AD=0.135
+ PS=1.27 PD=1.27
M$6 Y \$5 \$12 VPB sky130_fd_pr__pfet_01v8_hvt L=0.15 W=1 AS=0.135 AD=0.135
+ PS=1.27 PD=1.27
M$7 \$12 \$5 Y VPB sky130_fd_pr__pfet_01v8_hvt L=0.15 W=1 AS=0.135 AD=0.135
+ PS=1.27 PD=1.27
M$8 Y \$5 \$12 VPB sky130_fd_pr__pfet_01v8_hvt L=0.15 W=1 AS=0.135 AD=0.26
+ PS=1.27 PD=2.52
M$9 \$8 A VPWR VPB sky130_fd_pr__pfet_01v8_hvt L=0.15 W=1 AS=0.26 AD=0.135
+ PS=2.52 PD=1.27
M$10 VPWR A \$8 VPB sky130_fd_pr__pfet_01v8_hvt L=0.15 W=1 AS=0.135 AD=0.135
+ PS=1.27 PD=1.27
M$11 \$8 A VPWR VPB sky130_fd_pr__pfet_01v8_hvt L=0.15 W=1 AS=0.135 AD=0.135
+ PS=1.27 PD=1.27
M$12 VPWR A \$8 VPB sky130_fd_pr__pfet_01v8_hvt L=0.15 W=1 AS=0.135 AD=0.135
+ PS=1.27 PD=1.27
M$13 \$8 B \$11 VPB sky130_fd_pr__pfet_01v8_hvt L=0.15 W=1 AS=0.135 AD=0.135
+ PS=1.27 PD=1.27
M$14 \$11 B \$8 VPB sky130_fd_pr__pfet_01v8_hvt L=0.15 W=1 AS=0.135 AD=0.135
+ PS=1.27 PD=1.27
M$15 \$8 B \$11 VPB sky130_fd_pr__pfet_01v8_hvt L=0.15 W=1 AS=0.135 AD=0.135
+ PS=1.27 PD=1.27
M$16 \$11 B \$8 VPB sky130_fd_pr__pfet_01v8_hvt L=0.15 W=1 AS=0.135 AD=0.26
+ PS=1.27 PD=2.52
M$17 \$5 D_N VPWR VPB sky130_fd_pr__pfet_01v8_hvt L=0.15 W=1 AS=0.26 AD=0.28
+ PS=2.52 PD=2.56
M$18 \$5 D_N VGND VGND sky130_fd_pr__nfet_01v8 L=0.15 W=0.65 AS=0.169 AD=0.182
+ PS=1.82 PD=1.86
M$19 VGND A Y VGND sky130_fd_pr__nfet_01v8 L=0.15 W=0.65 AS=0.169 AD=0.08775
+ PS=1.82 PD=0.92
M$20 Y A VGND VGND sky130_fd_pr__nfet_01v8 L=0.15 W=0.65 AS=0.08775 AD=0.08775
+ PS=0.92 PD=0.92
M$21 VGND A Y VGND sky130_fd_pr__nfet_01v8 L=0.15 W=0.65 AS=0.08775 AD=0.08775
+ PS=0.92 PD=0.92
M$22 Y A VGND VGND sky130_fd_pr__nfet_01v8 L=0.15 W=0.65 AS=0.08775 AD=0.08775
+ PS=0.92 PD=0.92
M$23 VGND B Y VGND sky130_fd_pr__nfet_01v8 L=0.15 W=0.65 AS=0.08775 AD=0.08775
+ PS=0.92 PD=0.92
M$24 Y B VGND VGND sky130_fd_pr__nfet_01v8 L=0.15 W=0.65 AS=0.08775 AD=0.08775
+ PS=0.92 PD=0.92
M$25 VGND B Y VGND sky130_fd_pr__nfet_01v8 L=0.15 W=0.65 AS=0.08775 AD=0.08775
+ PS=0.92 PD=0.92
M$26 Y B VGND VGND sky130_fd_pr__nfet_01v8 L=0.15 W=0.65 AS=0.08775 AD=0.25675
+ PS=0.92 PD=1.44
M$27 VGND C Y VGND sky130_fd_pr__nfet_01v8 L=0.15 W=0.65 AS=0.25675 AD=0.08775
+ PS=1.44 PD=0.92
M$28 Y C VGND VGND sky130_fd_pr__nfet_01v8 L=0.15 W=0.65 AS=0.08775 AD=0.08775
+ PS=0.92 PD=0.92
M$29 VGND C Y VGND sky130_fd_pr__nfet_01v8 L=0.15 W=0.65 AS=0.08775 AD=0.08775
+ PS=0.92 PD=0.92
M$30 Y C VGND VGND sky130_fd_pr__nfet_01v8 L=0.15 W=0.65 AS=0.08775 AD=0.08775
+ PS=0.92 PD=0.92
M$31 VGND \$5 Y VGND sky130_fd_pr__nfet_01v8 L=0.15 W=0.65 AS=0.08775
+ AD=0.08775 PS=0.92 PD=0.92
M$32 Y \$5 VGND VGND sky130_fd_pr__nfet_01v8 L=0.15 W=0.65 AS=0.08775
+ AD=0.08775 PS=0.92 PD=0.92
M$33 VGND \$5 Y VGND sky130_fd_pr__nfet_01v8 L=0.15 W=0.65 AS=0.08775
+ AD=0.08775 PS=0.92 PD=0.92
M$34 Y \$5 VGND VGND sky130_fd_pr__nfet_01v8 L=0.15 W=0.65 AS=0.08775 AD=0.169
+ PS=0.92 PD=1.82
.ENDS sky130_fd_sc_hd__nor4b_4

.SUBCKT sky130_fd_sc_hd__nor4b_1 VPB VGND Y C B A VPWR D_N
M$1 VPWR D_N \$9 VPB sky130_fd_pr__pfet_01v8_hvt L=0.15 W=0.42 AS=0.14575
+ AD=0.1092 PS=1.335 PD=1.36
M$2 Y \$9 \$13 VPB sky130_fd_pr__pfet_01v8_hvt L=0.15 W=1 AS=0.52 AD=0.135
+ PS=3.04 PD=1.27
M$3 \$13 C \$12 VPB sky130_fd_pr__pfet_01v8_hvt L=0.15 W=1 AS=0.135 AD=0.165
+ PS=1.27 PD=1.33
M$4 \$12 B \$11 VPB sky130_fd_pr__pfet_01v8_hvt L=0.15 W=1 AS=0.165 AD=0.135
+ PS=1.33 PD=1.27
M$5 \$11 A VPWR VPB sky130_fd_pr__pfet_01v8_hvt L=0.15 W=1 AS=0.135 AD=0.14575
+ PS=1.27 PD=1.335
M$6 VGND \$9 Y VGND sky130_fd_pr__nfet_01v8 L=0.15 W=0.65 AS=0.182 AD=0.08775
+ PS=1.86 PD=0.92
M$7 Y C VGND VGND sky130_fd_pr__nfet_01v8 L=0.15 W=0.65 AS=0.08775 AD=0.10725
+ PS=0.92 PD=0.98
M$8 VGND B Y VGND sky130_fd_pr__nfet_01v8 L=0.15 W=0.65 AS=0.10725 AD=0.08775
+ PS=0.98 PD=0.92
M$9 Y A VGND VGND sky130_fd_pr__nfet_01v8 L=0.15 W=0.65 AS=0.08775 AD=0.10025
+ PS=0.92 PD=0.985
M$10 VGND D_N \$9 VGND sky130_fd_pr__nfet_01v8 L=0.15 W=0.42 AS=0.10025
+ AD=0.1092 PS=0.985 PD=1.36
.ENDS sky130_fd_sc_hd__nor4b_1

.SUBCKT sky130_fd_sc_hd__nor3b_2 VGND Y A B C_N VPWR VPB
M$1 \$8 A VPWR VPB sky130_fd_pr__pfet_01v8_hvt L=0.15 W=1 AS=0.28 AD=0.135
+ PS=2.56 PD=1.27
M$2 VPWR A \$8 VPB sky130_fd_pr__pfet_01v8_hvt L=0.15 W=1 AS=0.135 AD=0.135
+ PS=1.27 PD=1.27
M$3 \$8 B \$10 VPB sky130_fd_pr__pfet_01v8_hvt L=0.15 W=1 AS=0.135 AD=0.135
+ PS=1.27 PD=1.27
M$4 \$10 B \$8 VPB sky130_fd_pr__pfet_01v8_hvt L=0.15 W=1 AS=0.135 AD=0.28
+ PS=1.27 PD=2.56
M$5 \$10 \$6 Y VPB sky130_fd_pr__pfet_01v8_hvt L=0.15 W=1 AS=0.28 AD=0.135
+ PS=2.56 PD=1.27
M$6 Y \$6 \$10 VPB sky130_fd_pr__pfet_01v8_hvt L=0.15 W=1 AS=0.135 AD=0.28
+ PS=1.27 PD=2.56
M$7 \$6 C_N VPWR VPB sky130_fd_pr__pfet_01v8_hvt L=0.15 W=0.42 AS=0.1092
+ AD=0.1092 PS=1.36 PD=1.36
M$8 \$6 C_N VGND VGND sky130_fd_pr__nfet_01v8 L=0.15 W=0.42 AS=0.1092 AD=0.1092
+ PS=1.36 PD=1.36
M$9 VGND \$6 Y VGND sky130_fd_pr__nfet_01v8 L=0.15 W=0.65 AS=0.169 AD=0.08775
+ PS=1.82 PD=0.92
M$10 Y \$6 VGND VGND sky130_fd_pr__nfet_01v8 L=0.15 W=0.65 AS=0.08775 AD=0.182
+ PS=0.92 PD=1.86
M$11 VGND A Y VGND sky130_fd_pr__nfet_01v8 L=0.15 W=0.65 AS=0.182 AD=0.08775
+ PS=1.86 PD=0.92
M$12 Y A VGND VGND sky130_fd_pr__nfet_01v8 L=0.15 W=0.65 AS=0.08775 AD=0.08775
+ PS=0.92 PD=0.92
M$13 VGND B Y VGND sky130_fd_pr__nfet_01v8 L=0.15 W=0.65 AS=0.08775 AD=0.08775
+ PS=0.92 PD=0.92
M$14 Y B VGND VGND sky130_fd_pr__nfet_01v8 L=0.15 W=0.65 AS=0.08775 AD=0.169
+ PS=0.92 PD=1.82
.ENDS sky130_fd_sc_hd__nor3b_2

.SUBCKT sky130_fd_sc_hd__clkbuf_16 VGND A X VPWR VPB
M$1 VPWR A \$3 VPB sky130_fd_pr__pfet_01v8_hvt L=0.15 W=1 AS=0.265 AD=0.14
+ PS=2.53 PD=1.28
M$2 \$3 A VPWR VPB sky130_fd_pr__pfet_01v8_hvt L=0.15 W=1 AS=0.14 AD=0.14
+ PS=1.28 PD=1.28
M$3 VPWR A \$3 VPB sky130_fd_pr__pfet_01v8_hvt L=0.15 W=1 AS=0.14 AD=0.14
+ PS=1.28 PD=1.28
M$4 \$3 A VPWR VPB sky130_fd_pr__pfet_01v8_hvt L=0.15 W=1 AS=0.14 AD=0.14
+ PS=1.28 PD=1.28
M$5 VPWR \$3 X VPB sky130_fd_pr__pfet_01v8_hvt L=0.15 W=1 AS=0.14 AD=0.14
+ PS=1.28 PD=1.28
M$6 X \$3 VPWR VPB sky130_fd_pr__pfet_01v8_hvt L=0.15 W=1 AS=0.14 AD=0.14
+ PS=1.28 PD=1.28
M$7 VPWR \$3 X VPB sky130_fd_pr__pfet_01v8_hvt L=0.15 W=1 AS=0.14 AD=0.14
+ PS=1.28 PD=1.28
M$8 X \$3 VPWR VPB sky130_fd_pr__pfet_01v8_hvt L=0.15 W=1 AS=0.14 AD=0.14
+ PS=1.28 PD=1.28
M$9 VPWR \$3 X VPB sky130_fd_pr__pfet_01v8_hvt L=0.15 W=1 AS=0.14 AD=0.14
+ PS=1.28 PD=1.28
M$10 X \$3 VPWR VPB sky130_fd_pr__pfet_01v8_hvt L=0.15 W=1 AS=0.14 AD=0.14
+ PS=1.28 PD=1.28
M$11 VPWR \$3 X VPB sky130_fd_pr__pfet_01v8_hvt L=0.15 W=1 AS=0.14 AD=0.14
+ PS=1.28 PD=1.28
M$12 X \$3 VPWR VPB sky130_fd_pr__pfet_01v8_hvt L=0.15 W=1 AS=0.14 AD=0.1375
+ PS=1.28 PD=1.275
M$13 VPWR \$3 X VPB sky130_fd_pr__pfet_01v8_hvt L=0.15 W=1 AS=0.1375 AD=0.14
+ PS=1.275 PD=1.28
M$14 X \$3 VPWR VPB sky130_fd_pr__pfet_01v8_hvt L=0.15 W=1 AS=0.14 AD=0.14
+ PS=1.28 PD=1.28
M$15 VPWR \$3 X VPB sky130_fd_pr__pfet_01v8_hvt L=0.15 W=1 AS=0.14 AD=0.14
+ PS=1.28 PD=1.28
M$16 X \$3 VPWR VPB sky130_fd_pr__pfet_01v8_hvt L=0.15 W=1 AS=0.14 AD=0.14
+ PS=1.28 PD=1.28
M$17 VPWR \$3 X VPB sky130_fd_pr__pfet_01v8_hvt L=0.15 W=1 AS=0.14 AD=0.14
+ PS=1.28 PD=1.28
M$18 X \$3 VPWR VPB sky130_fd_pr__pfet_01v8_hvt L=0.15 W=1 AS=0.14 AD=0.14
+ PS=1.28 PD=1.28
M$19 VPWR \$3 X VPB sky130_fd_pr__pfet_01v8_hvt L=0.15 W=1 AS=0.14 AD=0.14
+ PS=1.28 PD=1.28
M$20 X \$3 VPWR VPB sky130_fd_pr__pfet_01v8_hvt L=0.15 W=1 AS=0.14 AD=0.265
+ PS=1.28 PD=2.53
M$21 VGND A \$3 VGND sky130_fd_pr__nfet_01v8 L=0.15 W=0.42 AS=0.1113 AD=0.0588
+ PS=1.37 PD=0.7
M$22 \$3 A VGND VGND sky130_fd_pr__nfet_01v8 L=0.15 W=0.42 AS=0.0588 AD=0.0588
+ PS=0.7 PD=0.7
M$23 VGND A \$3 VGND sky130_fd_pr__nfet_01v8 L=0.15 W=0.42 AS=0.0588 AD=0.0588
+ PS=0.7 PD=0.7
M$24 \$3 A VGND VGND sky130_fd_pr__nfet_01v8 L=0.15 W=0.42 AS=0.0588 AD=0.0588
+ PS=0.7 PD=0.7
M$25 VGND \$3 X VGND sky130_fd_pr__nfet_01v8 L=0.15 W=0.42 AS=0.0588 AD=0.0588
+ PS=0.7 PD=0.7
M$26 X \$3 VGND VGND sky130_fd_pr__nfet_01v8 L=0.15 W=0.42 AS=0.0588 AD=0.0588
+ PS=0.7 PD=0.7
M$27 VGND \$3 X VGND sky130_fd_pr__nfet_01v8 L=0.15 W=0.42 AS=0.0588 AD=0.0588
+ PS=0.7 PD=0.7
M$28 X \$3 VGND VGND sky130_fd_pr__nfet_01v8 L=0.15 W=0.42 AS=0.0588 AD=0.0588
+ PS=0.7 PD=0.7
M$29 VGND \$3 X VGND sky130_fd_pr__nfet_01v8 L=0.15 W=0.42 AS=0.0588 AD=0.0588
+ PS=0.7 PD=0.7
M$30 X \$3 VGND VGND sky130_fd_pr__nfet_01v8 L=0.15 W=0.42 AS=0.0588 AD=0.0588
+ PS=0.7 PD=0.7
M$31 VGND \$3 X VGND sky130_fd_pr__nfet_01v8 L=0.15 W=0.42 AS=0.0588 AD=0.0588
+ PS=0.7 PD=0.7
M$32 X \$3 VGND VGND sky130_fd_pr__nfet_01v8 L=0.15 W=0.42 AS=0.0588 AD=0.05775
+ PS=0.7 PD=0.695
M$33 VGND \$3 X VGND sky130_fd_pr__nfet_01v8 L=0.15 W=0.42 AS=0.05775 AD=0.0588
+ PS=0.695 PD=0.7
M$34 X \$3 VGND VGND sky130_fd_pr__nfet_01v8 L=0.15 W=0.42 AS=0.0588 AD=0.0588
+ PS=0.7 PD=0.7
M$35 VGND \$3 X VGND sky130_fd_pr__nfet_01v8 L=0.15 W=0.42 AS=0.0588 AD=0.0588
+ PS=0.7 PD=0.7
M$36 X \$3 VGND VGND sky130_fd_pr__nfet_01v8 L=0.15 W=0.42 AS=0.0588 AD=0.0588
+ PS=0.7 PD=0.7
M$37 VGND \$3 X VGND sky130_fd_pr__nfet_01v8 L=0.15 W=0.42 AS=0.0588 AD=0.0588
+ PS=0.7 PD=0.7
M$38 X \$3 VGND VGND sky130_fd_pr__nfet_01v8 L=0.15 W=0.42 AS=0.0588 AD=0.0588
+ PS=0.7 PD=0.7
M$39 VGND \$3 X VGND sky130_fd_pr__nfet_01v8 L=0.15 W=0.42 AS=0.0588 AD=0.0588
+ PS=0.7 PD=0.7
M$40 X \$3 VGND VGND sky130_fd_pr__nfet_01v8 L=0.15 W=0.42 AS=0.0588 AD=0.1113
+ PS=0.7 PD=1.37
.ENDS sky130_fd_sc_hd__clkbuf_16

.SUBCKT sky130_fd_sc_hd__dfrtp_1 VGND RESET_B Q CLK D VPWR VPB
M$1 VPWR \$8 Q VPB sky130_fd_pr__pfet_01v8_hvt L=0.15 W=1 AS=0.3012 AD=0.26
+ PS=2.66 PD=2.52
M$2 \$3 CLK VPWR VPB sky130_fd_pr__pfet_01v8_hvt L=0.15 W=0.64 AS=0.1664
+ AD=0.0864 PS=1.8 PD=0.91
M$3 VPWR \$3 \$15 VPB sky130_fd_pr__pfet_01v8_hvt L=0.15 W=0.64 AS=0.0864
+ AD=0.1664 PS=0.91 PD=1.8
M$4 VPWR \$5 \$17 VPB sky130_fd_pr__pfet_01v8_hvt L=0.15 W=0.84 AS=0.2184
+ AD=0.12915 PS=2.2 PD=1.185
M$5 \$17 \$3 \$7 VPB sky130_fd_pr__pfet_01v8_hvt L=0.15 W=0.42 AS=0.12915
+ AD=0.0588 PS=1.185 PD=0.7
M$6 \$7 \$15 \$21 VPB sky130_fd_pr__pfet_01v8_hvt L=0.15 W=0.42 AS=0.0588
+ AD=0.0567 PS=0.7 PD=0.69
M$7 \$21 \$8 VPWR VPB sky130_fd_pr__pfet_01v8_hvt L=0.15 W=0.42 AS=0.0567
+ AD=0.0819 PS=0.69 PD=0.81
M$8 VPWR RESET_B \$8 VPB sky130_fd_pr__pfet_01v8_hvt L=0.15 W=0.42 AS=0.0819
+ AD=0.0567 PS=0.81 PD=0.69
M$9 \$8 \$7 VPWR VPB sky130_fd_pr__pfet_01v8_hvt L=0.15 W=0.42 AS=0.0567
+ AD=0.1134 PS=0.69 PD=1.38
M$10 VPWR D \$4 VPB sky130_fd_pr__pfet_01v8_hvt L=0.15 W=0.42 AS=0.1092
+ AD=0.0651 PS=1.36 PD=0.73
M$11 \$4 \$15 \$5 VPB sky130_fd_pr__pfet_01v8_hvt L=0.15 W=0.42 AS=0.0651
+ AD=0.07245 PS=0.73 PD=0.765
M$12 \$5 \$3 \$19 VPB sky130_fd_pr__pfet_01v8_hvt L=0.15 W=0.42 AS=0.07245
+ AD=0.1155 PS=0.765 PD=0.97
M$13 \$19 \$17 VPWR VPB sky130_fd_pr__pfet_01v8_hvt L=0.15 W=0.42 AS=0.1155
+ AD=0.07035 PS=0.97 PD=0.755
M$14 VPWR RESET_B \$19 VPB sky130_fd_pr__pfet_01v8_hvt L=0.15 W=0.42 AS=0.07035
+ AD=0.1092 PS=0.755 PD=1.36
M$15 VGND \$8 Q VGND sky130_fd_pr__nfet_01v8 L=0.15 W=0.65 AS=0.2087 AD=0.169
+ PS=2.02 PD=1.82
M$16 \$3 CLK VGND VGND sky130_fd_pr__nfet_01v8 L=0.15 W=0.42 AS=0.1092
+ AD=0.0567 PS=1.36 PD=0.69
M$17 VGND \$3 \$15 VGND sky130_fd_pr__nfet_01v8 L=0.15 W=0.42 AS=0.0567
+ AD=0.1092 PS=0.69 PD=1.36
M$18 \$4 \$3 \$5 VGND sky130_fd_pr__nfet_01v8 L=0.15 W=0.36 AS=0.066 AD=0.0594
+ PS=0.745 PD=0.69
M$19 \$5 \$15 \$12 VGND sky130_fd_pr__nfet_01v8 L=0.15 W=0.36 AS=0.0594
+ AD=0.1401 PS=0.69 PD=1.1
M$20 \$17 \$15 \$7 VGND sky130_fd_pr__nfet_01v8 L=0.15 W=0.36 AS=0.0999
+ AD=0.0711 PS=0.985 PD=0.755
M$21 \$7 \$3 \$11 VGND sky130_fd_pr__nfet_01v8 L=0.15 W=0.36 AS=0.0711
+ AD=0.0669 PS=0.755 PD=0.75
M$22 VGND D \$4 VGND sky130_fd_pr__nfet_01v8 L=0.15 W=0.42 AS=0.2205 AD=0.066
+ PS=1.89 PD=0.745
M$23 \$12 \$17 \$13 VGND sky130_fd_pr__nfet_01v8 L=0.15 W=0.42 AS=0.1401
+ AD=0.0441 PS=1.1 PD=0.63
M$24 \$13 RESET_B VGND VGND sky130_fd_pr__nfet_01v8 L=0.15 W=0.42 AS=0.0441
+ AD=0.1346 PS=0.63 PD=1.15
M$25 \$11 \$8 VGND VGND sky130_fd_pr__nfet_01v8 L=0.15 W=0.42 AS=0.0669
+ AD=0.12495 PS=0.75 PD=1.015
M$26 VGND RESET_B \$10 VGND sky130_fd_pr__nfet_01v8 L=0.15 W=0.42 AS=0.12495
+ AD=0.06405 PS=1.015 PD=0.725
M$27 \$10 \$7 \$8 VGND sky130_fd_pr__nfet_01v8 L=0.15 W=0.42 AS=0.06405
+ AD=0.1092 PS=0.725 PD=1.36
M$28 VGND \$5 \$17 VGND sky130_fd_pr__nfet_01v8 L=0.15 W=0.64 AS=0.1346
+ AD=0.0999 PS=1.15 PD=0.985
.ENDS sky130_fd_sc_hd__dfrtp_1

.SUBCKT sky130_fd_sc_hd__mux2_1 VGND X A1 A0 S VPWR VPB
M$1 VPWR S \$13 VPB sky130_fd_pr__pfet_01v8_hvt L=0.15 W=0.42 AS=0.15835
+ AD=0.07665 PS=1.395 PD=0.785
M$2 \$13 A0 \$5 VPB sky130_fd_pr__pfet_01v8_hvt L=0.15 W=0.42 AS=0.07665
+ AD=0.1932 PS=0.785 PD=1.34
M$3 \$5 A1 \$14 VPB sky130_fd_pr__pfet_01v8_hvt L=0.15 W=0.42 AS=0.1932
+ AD=0.0441 PS=1.34 PD=0.63
M$4 \$14 \$7 VPWR VPB sky130_fd_pr__pfet_01v8_hvt L=0.15 W=0.42 AS=0.0441
+ AD=0.0693 PS=0.63 PD=0.75
M$5 VPWR S \$7 VPB sky130_fd_pr__pfet_01v8_hvt L=0.15 W=0.42 AS=0.0693
+ AD=0.1176 PS=0.75 PD=1.4
M$6 X \$5 VPWR VPB sky130_fd_pr__pfet_01v8_hvt L=0.15 W=1 AS=0.26 AD=0.15835
+ PS=2.52 PD=1.395
M$7 VGND S \$8 VGND sky130_fd_pr__nfet_01v8 L=0.15 W=0.42 AS=0.11285 AD=0.0693
+ PS=1.045 PD=0.75
M$8 \$8 A1 \$5 VGND sky130_fd_pr__nfet_01v8 L=0.15 W=0.42 AS=0.0693 AD=0.09975
+ PS=0.75 PD=0.895
M$9 \$5 A0 \$9 VGND sky130_fd_pr__nfet_01v8 L=0.15 W=0.42 AS=0.09975 AD=0.0693
+ PS=0.895 PD=0.75
M$10 \$9 \$7 VGND VGND sky130_fd_pr__nfet_01v8 L=0.15 W=0.42 AS=0.0693
+ AD=0.1449 PS=0.75 PD=1.11
M$11 VGND S \$7 VGND sky130_fd_pr__nfet_01v8 L=0.15 W=0.42 AS=0.1449 AD=0.1092
+ PS=1.11 PD=1.36
M$12 X \$5 VGND VGND sky130_fd_pr__nfet_01v8 L=0.15 W=0.65 AS=0.169 AD=0.11285
+ PS=1.82 PD=1.045
.ENDS sky130_fd_sc_hd__mux2_1

.SUBCKT sky130_fd_sc_hd__a22oi_1 VPB A1 VPWR Y B1 B2 VGND A2
M$1 VPWR A1 \$2 VPB sky130_fd_pr__pfet_01v8_hvt L=0.15 W=1 AS=0.26 AD=0.135
+ PS=2.52 PD=1.27
M$2 \$2 A2 VPWR VPB sky130_fd_pr__pfet_01v8_hvt L=0.15 W=1 AS=0.135 AD=0.3
+ PS=1.27 PD=2.6
M$3 Y B2 \$2 VPB sky130_fd_pr__pfet_01v8_hvt L=0.15 W=1 AS=0.26 AD=0.135
+ PS=2.52 PD=1.27
M$4 \$2 B1 Y VPB sky130_fd_pr__pfet_01v8_hvt L=0.15 W=1 AS=0.135 AD=0.26
+ PS=1.27 PD=2.52
M$5 Y A1 \$11 VGND sky130_fd_pr__nfet_01v8 L=0.15 W=0.65 AS=0.169 AD=0.06825
+ PS=1.82 PD=0.86
M$6 \$11 A2 VGND VGND sky130_fd_pr__nfet_01v8 L=0.15 W=0.65 AS=0.06825 AD=0.234
+ PS=0.86 PD=2.02
M$7 VGND B2 \$12 VGND sky130_fd_pr__nfet_01v8 L=0.15 W=0.65 AS=0.169 AD=0.07475
+ PS=1.82 PD=0.88
M$8 \$12 B1 Y VGND sky130_fd_pr__nfet_01v8 L=0.15 W=0.65 AS=0.07475 AD=0.169
+ PS=0.88 PD=1.82
.ENDS sky130_fd_sc_hd__a22oi_1

.SUBCKT sky130_fd_sc_hd__o21ai_0 VPB VPWR Y A1 VGND A2 B1
M$1 VPWR A1 \$10 VPB sky130_fd_pr__pfet_01v8_hvt L=0.15 W=0.64 AS=0.1696
+ AD=0.0768 PS=1.81 PD=0.88
M$2 \$10 A2 Y VPB sky130_fd_pr__pfet_01v8_hvt L=0.15 W=0.64 AS=0.0768 AD=0.0896
+ PS=0.88 PD=0.92
M$3 Y B1 VPWR VPB sky130_fd_pr__pfet_01v8_hvt L=0.15 W=0.64 AS=0.0896 AD=0.1824
+ PS=0.92 PD=1.85
M$4 \$5 A1 VGND VGND sky130_fd_pr__nfet_01v8 L=0.15 W=0.42 AS=0.1113 AD=0.0588
+ PS=1.37 PD=0.7
M$5 VGND A2 \$5 VGND sky130_fd_pr__nfet_01v8 L=0.15 W=0.42 AS=0.0588 AD=0.0588
+ PS=0.7 PD=0.7
M$6 \$5 B1 Y VGND sky130_fd_pr__nfet_01v8 L=0.15 W=0.42 AS=0.0588 AD=0.1113
+ PS=0.7 PD=1.37
.ENDS sky130_fd_sc_hd__o21ai_0

.SUBCKT sky130_fd_sc_hd__nor2_2 VPB VGND A Y B VPWR
M$1 \$3 A VPWR VPB sky130_fd_pr__pfet_01v8_hvt L=0.15 W=1 AS=0.28 AD=0.135
+ PS=2.56 PD=1.27
M$2 VPWR A \$3 VPB sky130_fd_pr__pfet_01v8_hvt L=0.15 W=1 AS=0.135 AD=0.135
+ PS=1.27 PD=1.27
M$3 \$3 B Y VPB sky130_fd_pr__pfet_01v8_hvt L=0.15 W=1 AS=0.135 AD=0.135
+ PS=1.27 PD=1.27
M$4 Y B \$3 VPB sky130_fd_pr__pfet_01v8_hvt L=0.15 W=1 AS=0.135 AD=0.26 PS=1.27
+ PD=2.52
M$5 VGND A Y VGND sky130_fd_pr__nfet_01v8 L=0.15 W=0.65 AS=0.182 AD=0.08775
+ PS=1.86 PD=0.92
M$6 Y A VGND VGND sky130_fd_pr__nfet_01v8 L=0.15 W=0.65 AS=0.08775 AD=0.08775
+ PS=0.92 PD=0.92
M$7 VGND B Y VGND sky130_fd_pr__nfet_01v8 L=0.15 W=0.65 AS=0.08775 AD=0.08775
+ PS=0.92 PD=0.92
M$8 Y B VGND VGND sky130_fd_pr__nfet_01v8 L=0.15 W=0.65 AS=0.08775 AD=0.169
+ PS=0.92 PD=1.82
.ENDS sky130_fd_sc_hd__nor2_2

.SUBCKT sky130_fd_sc_hd__nand2_1 VPB Y VPWR VGND A B
M$1 VPWR B Y VPB sky130_fd_pr__pfet_01v8_hvt L=0.15 W=1 AS=0.26 AD=0.135
+ PS=2.52 PD=1.27
M$2 Y A VPWR VPB sky130_fd_pr__pfet_01v8_hvt L=0.15 W=1 AS=0.135 AD=0.26
+ PS=1.27 PD=2.52
M$3 VGND B \$8 VGND sky130_fd_pr__nfet_01v8 L=0.15 W=0.65 AS=0.169 AD=0.08775
+ PS=1.82 PD=0.92
M$4 \$8 A Y VGND sky130_fd_pr__nfet_01v8 L=0.15 W=0.65 AS=0.08775 AD=0.169
+ PS=0.92 PD=1.82
.ENDS sky130_fd_sc_hd__nand2_1

.SUBCKT sky130_fd_sc_hd__buf_2 VPB VGND X VPWR A
M$1 VPWR A \$3 VPB sky130_fd_pr__pfet_01v8_hvt L=0.15 W=0.64 AS=0.149 AD=0.1664
+ PS=1.325 PD=1.8
M$2 VPWR \$3 X VPB sky130_fd_pr__pfet_01v8_hvt L=0.15 W=1 AS=0.149 AD=0.135
+ PS=1.325 PD=1.27
M$3 X \$3 VPWR VPB sky130_fd_pr__pfet_01v8_hvt L=0.15 W=1 AS=0.135 AD=0.265
+ PS=1.27 PD=2.53
M$4 \$3 A VGND VGND sky130_fd_pr__nfet_01v8 L=0.15 W=0.42 AS=0.1092 AD=0.097
+ PS=1.36 PD=0.975
M$5 VGND \$3 X VGND sky130_fd_pr__nfet_01v8 L=0.15 W=0.65 AS=0.097 AD=0.08775
+ PS=0.975 PD=0.92
M$6 X \$3 VGND VGND sky130_fd_pr__nfet_01v8 L=0.15 W=0.65 AS=0.08775 AD=0.17225
+ PS=0.92 PD=1.83
.ENDS sky130_fd_sc_hd__buf_2

.SUBCKT sky130_fd_sc_hd__buf_6 VGND A X VPWR VPB
M$1 VPWR A \$2 VPB sky130_fd_pr__pfet_01v8_hvt L=0.15 W=1 AS=0.26 AD=0.135
+ PS=2.52 PD=1.27
M$2 \$2 A VPWR VPB sky130_fd_pr__pfet_01v8_hvt L=0.15 W=1 AS=0.135 AD=0.135
+ PS=1.27 PD=1.27
M$3 VPWR \$2 X VPB sky130_fd_pr__pfet_01v8_hvt L=0.15 W=1 AS=0.135 AD=0.135
+ PS=1.27 PD=1.27
M$4 X \$2 VPWR VPB sky130_fd_pr__pfet_01v8_hvt L=0.15 W=1 AS=0.135 AD=0.135
+ PS=1.27 PD=1.27
M$5 VPWR \$2 X VPB sky130_fd_pr__pfet_01v8_hvt L=0.15 W=1 AS=0.135 AD=0.135
+ PS=1.27 PD=1.27
M$6 X \$2 VPWR VPB sky130_fd_pr__pfet_01v8_hvt L=0.15 W=1 AS=0.135 AD=0.135
+ PS=1.27 PD=1.27
M$7 VPWR \$2 X VPB sky130_fd_pr__pfet_01v8_hvt L=0.15 W=1 AS=0.135 AD=0.135
+ PS=1.27 PD=1.27
M$8 X \$2 VPWR VPB sky130_fd_pr__pfet_01v8_hvt L=0.15 W=1 AS=0.135 AD=0.26
+ PS=1.27 PD=2.52
M$9 VGND A \$2 VGND sky130_fd_pr__nfet_01v8 L=0.15 W=0.65 AS=0.169 AD=0.08775
+ PS=1.82 PD=0.92
M$10 \$2 A VGND VGND sky130_fd_pr__nfet_01v8 L=0.15 W=0.65 AS=0.08775
+ AD=0.08775 PS=0.92 PD=0.92
M$11 VGND \$2 X VGND sky130_fd_pr__nfet_01v8 L=0.15 W=0.65 AS=0.08775
+ AD=0.08775 PS=0.92 PD=0.92
M$12 X \$2 VGND VGND sky130_fd_pr__nfet_01v8 L=0.15 W=0.65 AS=0.08775
+ AD=0.08775 PS=0.92 PD=0.92
M$13 VGND \$2 X VGND sky130_fd_pr__nfet_01v8 L=0.15 W=0.65 AS=0.08775
+ AD=0.08775 PS=0.92 PD=0.92
M$14 X \$2 VGND VGND sky130_fd_pr__nfet_01v8 L=0.15 W=0.65 AS=0.08775
+ AD=0.08775 PS=0.92 PD=0.92
M$15 VGND \$2 X VGND sky130_fd_pr__nfet_01v8 L=0.15 W=0.65 AS=0.08775
+ AD=0.08775 PS=0.92 PD=0.92
M$16 X \$2 VGND VGND sky130_fd_pr__nfet_01v8 L=0.15 W=0.65 AS=0.08775 AD=0.169
+ PS=0.92 PD=1.82
.ENDS sky130_fd_sc_hd__buf_6

.SUBCKT sky130_fd_sc_hd__mux2_4 VGND S A0 A1 X VPWR VPB
M$1 \$13 S VPWR VPB sky130_fd_pr__pfet_01v8_hvt L=0.15 W=1 AS=0.26 AD=0.135
+ PS=2.52 PD=1.27
M$2 VPWR \$6 X VPB sky130_fd_pr__pfet_01v8_hvt L=0.15 W=1 AS=0.135 AD=0.135
+ PS=1.27 PD=1.27
M$3 X \$6 VPWR VPB sky130_fd_pr__pfet_01v8_hvt L=0.15 W=1 AS=0.135 AD=0.135
+ PS=1.27 PD=1.27
M$4 VPWR \$6 X VPB sky130_fd_pr__pfet_01v8_hvt L=0.15 W=1 AS=0.135 AD=0.135
+ PS=1.27 PD=1.27
M$5 X \$6 VPWR VPB sky130_fd_pr__pfet_01v8_hvt L=0.15 W=1 AS=0.135 AD=0.26
+ PS=1.27 PD=2.52
M$6 \$13 A0 \$6 VPB sky130_fd_pr__pfet_01v8_hvt L=0.15 W=1 AS=0.26 AD=0.16
+ PS=2.52 PD=1.32
M$7 \$6 A1 \$12 VPB sky130_fd_pr__pfet_01v8_hvt L=0.15 W=1 AS=0.16 AD=0.3
+ PS=1.32 PD=2.6
M$8 \$3 S VPWR VPB sky130_fd_pr__pfet_01v8_hvt L=0.15 W=1 AS=0.26 AD=0.1625
+ PS=2.52 PD=1.325
M$9 VPWR \$3 \$12 VPB sky130_fd_pr__pfet_01v8_hvt L=0.15 W=1 AS=0.1625 AD=0.28
+ PS=1.325 PD=2.56
M$10 \$3 S VGND VGND sky130_fd_pr__nfet_01v8 L=0.15 W=0.65 AS=0.169 AD=0.108875
+ PS=1.82 PD=0.985
M$11 VGND \$3 \$9 VGND sky130_fd_pr__nfet_01v8 L=0.15 W=0.65 AS=0.108875
+ AD=0.26 PS=0.985 PD=1.45
M$12 \$9 A0 \$6 VGND sky130_fd_pr__nfet_01v8 L=0.15 W=0.65 AS=0.26 AD=0.104
+ PS=1.45 PD=0.97
M$13 \$6 A1 \$10 VGND sky130_fd_pr__nfet_01v8 L=0.15 W=0.65 AS=0.104
+ AD=0.274625 PS=0.97 PD=1.495
M$14 \$10 S VGND VGND sky130_fd_pr__nfet_01v8 L=0.15 W=0.65 AS=0.274625
+ AD=0.08775 PS=1.495 PD=0.92
M$15 VGND \$6 X VGND sky130_fd_pr__nfet_01v8 L=0.15 W=0.65 AS=0.08775
+ AD=0.08775 PS=0.92 PD=0.92
M$16 X \$6 VGND VGND sky130_fd_pr__nfet_01v8 L=0.15 W=0.65 AS=0.08775
+ AD=0.08775 PS=0.92 PD=0.92
M$17 VGND \$6 X VGND sky130_fd_pr__nfet_01v8 L=0.15 W=0.65 AS=0.08775
+ AD=0.08775 PS=0.92 PD=0.92
M$18 X \$6 VGND VGND sky130_fd_pr__nfet_01v8 L=0.15 W=0.65 AS=0.08775 AD=0.169
+ PS=0.92 PD=1.82
.ENDS sky130_fd_sc_hd__mux2_4

.SUBCKT sky130_fd_sc_hd__nor4_4 VGND A B C D Y VPWR VPB
M$1 \$11 C \$10 VPB sky130_fd_pr__pfet_01v8_hvt L=0.15 W=1 AS=0.26 AD=0.135
+ PS=2.52 PD=1.27
M$2 \$10 C \$11 VPB sky130_fd_pr__pfet_01v8_hvt L=0.15 W=1 AS=0.135 AD=0.135
+ PS=1.27 PD=1.27
M$3 \$11 C \$10 VPB sky130_fd_pr__pfet_01v8_hvt L=0.15 W=1 AS=0.135 AD=0.135
+ PS=1.27 PD=1.27
M$4 \$10 C \$11 VPB sky130_fd_pr__pfet_01v8_hvt L=0.15 W=1 AS=0.135 AD=0.135
+ PS=1.27 PD=1.27
M$5 \$11 D Y VPB sky130_fd_pr__pfet_01v8_hvt L=0.15 W=1 AS=0.135 AD=0.135
+ PS=1.27 PD=1.27
M$6 Y D \$11 VPB sky130_fd_pr__pfet_01v8_hvt L=0.15 W=1 AS=0.135 AD=0.135
+ PS=1.27 PD=1.27
M$7 \$11 D Y VPB sky130_fd_pr__pfet_01v8_hvt L=0.15 W=1 AS=0.135 AD=0.135
+ PS=1.27 PD=1.27
M$8 Y D \$11 VPB sky130_fd_pr__pfet_01v8_hvt L=0.15 W=1 AS=0.135 AD=0.26
+ PS=1.27 PD=2.52
M$9 \$8 A VPWR VPB sky130_fd_pr__pfet_01v8_hvt L=0.15 W=1 AS=0.28 AD=0.135
+ PS=2.56 PD=1.27
M$10 VPWR A \$8 VPB sky130_fd_pr__pfet_01v8_hvt L=0.15 W=1 AS=0.135 AD=0.135
+ PS=1.27 PD=1.27
M$11 \$8 A VPWR VPB sky130_fd_pr__pfet_01v8_hvt L=0.15 W=1 AS=0.135 AD=0.135
+ PS=1.27 PD=1.27
M$12 VPWR A \$8 VPB sky130_fd_pr__pfet_01v8_hvt L=0.15 W=1 AS=0.135 AD=0.135
+ PS=1.27 PD=1.27
M$13 \$8 B \$10 VPB sky130_fd_pr__pfet_01v8_hvt L=0.15 W=1 AS=0.135 AD=0.135
+ PS=1.27 PD=1.27
M$14 \$10 B \$8 VPB sky130_fd_pr__pfet_01v8_hvt L=0.15 W=1 AS=0.135 AD=0.135
+ PS=1.27 PD=1.27
M$15 \$8 B \$10 VPB sky130_fd_pr__pfet_01v8_hvt L=0.15 W=1 AS=0.135 AD=0.135
+ PS=1.27 PD=1.27
M$16 \$10 B \$8 VPB sky130_fd_pr__pfet_01v8_hvt L=0.15 W=1 AS=0.135 AD=0.26
+ PS=1.27 PD=2.52
M$17 VGND A Y VGND sky130_fd_pr__nfet_01v8 L=0.15 W=0.65 AS=0.182 AD=0.08775
+ PS=1.86 PD=0.92
M$18 Y A VGND VGND sky130_fd_pr__nfet_01v8 L=0.15 W=0.65 AS=0.08775 AD=0.08775
+ PS=0.92 PD=0.92
M$19 VGND A Y VGND sky130_fd_pr__nfet_01v8 L=0.15 W=0.65 AS=0.08775 AD=0.08775
+ PS=0.92 PD=0.92
M$20 Y A VGND VGND sky130_fd_pr__nfet_01v8 L=0.15 W=0.65 AS=0.08775 AD=0.08775
+ PS=0.92 PD=0.92
M$21 VGND B Y VGND sky130_fd_pr__nfet_01v8 L=0.15 W=0.65 AS=0.08775 AD=0.08775
+ PS=0.92 PD=0.92
M$22 Y B VGND VGND sky130_fd_pr__nfet_01v8 L=0.15 W=0.65 AS=0.08775 AD=0.08775
+ PS=0.92 PD=0.92
M$23 VGND B Y VGND sky130_fd_pr__nfet_01v8 L=0.15 W=0.65 AS=0.08775 AD=0.08775
+ PS=0.92 PD=0.92
M$24 Y B VGND VGND sky130_fd_pr__nfet_01v8 L=0.15 W=0.65 AS=0.08775 AD=0.25675
+ PS=0.92 PD=1.44
M$25 VGND C Y VGND sky130_fd_pr__nfet_01v8 L=0.15 W=0.65 AS=0.25675 AD=0.08775
+ PS=1.44 PD=0.92
M$26 Y C VGND VGND sky130_fd_pr__nfet_01v8 L=0.15 W=0.65 AS=0.08775 AD=0.08775
+ PS=0.92 PD=0.92
M$27 VGND C Y VGND sky130_fd_pr__nfet_01v8 L=0.15 W=0.65 AS=0.08775 AD=0.08775
+ PS=0.92 PD=0.92
M$28 Y C VGND VGND sky130_fd_pr__nfet_01v8 L=0.15 W=0.65 AS=0.08775 AD=0.08775
+ PS=0.92 PD=0.92
M$29 VGND D Y VGND sky130_fd_pr__nfet_01v8 L=0.15 W=0.65 AS=0.08775 AD=0.08775
+ PS=0.92 PD=0.92
M$30 Y D VGND VGND sky130_fd_pr__nfet_01v8 L=0.15 W=0.65 AS=0.08775 AD=0.08775
+ PS=0.92 PD=0.92
M$31 VGND D Y VGND sky130_fd_pr__nfet_01v8 L=0.15 W=0.65 AS=0.08775 AD=0.08775
+ PS=0.92 PD=0.92
M$32 Y D VGND VGND sky130_fd_pr__nfet_01v8 L=0.15 W=0.65 AS=0.08775 AD=0.169
+ PS=0.92 PD=1.82
.ENDS sky130_fd_sc_hd__nor4_4

.SUBCKT sky130_fd_sc_hd__tapvpwrvgnd_1 VPWR VGND
.ENDS sky130_fd_sc_hd__tapvpwrvgnd_1

.SUBCKT sky130_fd_sc_hd__fill_1 VPB VPWR VGND
.ENDS sky130_fd_sc_hd__fill_1

.SUBCKT sky130_fd_sc_hd__fill_4 VPB VPWR VGND
.ENDS sky130_fd_sc_hd__fill_4

.SUBCKT sky130_fd_sc_hd__fill_2 VPB VPWR VGND
.ENDS sky130_fd_sc_hd__fill_2

.SUBCKT sky130_fd_sc_hd__fill_8 VPB VPWR VGND
.ENDS sky130_fd_sc_hd__fill_8

.SUBCKT VIA_via5_6_1600_1600_1_1_1600_1600 \$1
.ENDS VIA_via5_6_1600_1600_1_1_1600_1600

.SUBCKT VIA_M2M3_PR \$1
.ENDS VIA_M2M3_PR

.SUBCKT VIA_M1M2_PR \$1
.ENDS VIA_M1M2_PR

.SUBCKT VIA_L1M1_PR_MR \$1
.ENDS VIA_L1M1_PR_MR

.SUBCKT VIA_via2_3_1600_480_1_5_320_320 \$1
.ENDS VIA_via2_3_1600_480_1_5_320_320

.SUBCKT VIA_via3_4_1600_480_1_4_400_400 \$1
.ENDS VIA_via3_4_1600_480_1_4_400_400

.SUBCKT VIA_via4_5_1600_480_1_4_400_400 \$1
.ENDS VIA_via4_5_1600_480_1_4_400_400
