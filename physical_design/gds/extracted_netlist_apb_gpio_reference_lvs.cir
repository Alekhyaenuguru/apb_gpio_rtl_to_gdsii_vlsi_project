* Extracted by KLayout with SKY130 LVS runset on : 15/10/2026 20:34

.SUBCKT apb_gpio A0|B2|Q|gpio_oe[3] A1|gpio_in[1] A1|PWDATA[0]
+ A0|B2|Q|gpio_oe[0] A1|gpio_in[6] A|A2|C|D_N|X A|X D|X S|X B|B1|Y HI|VPB|VPWR
+ A1|Y PRDATA[0]|Y A1|gpio_in[0] PRDATA[6]|Y A0|B2|Q|gpio_oe[1] CLK|X A2|Y
+ A|B1|X A|PADDR[2] PRESETn|RESET_B PRDATA[1]|Y A0|A1|Q|gpio_out[0]
+ A1|PWDATA[1] A0|A1|Q|gpio_out[1] A0|A1|Q|gpio_out[3] B|B1|B_N|Y A2|B|C2|Y
+ A1|PWDATA[3] A1|PWDATA[6] A0|B2|Q|gpio_oe[6] A1|gpio_in[3] PRDATA[3]|Y
+ A0|A1|Q|gpio_out[6] B|PREADY|X A|Y A|A_N|Y A_N|C|PWRITE A|PSEL B|PENABLE
+ A0|A1|Q|gpio_out[2] A1|gpio_in[2] B|PADDR[5] C|C_N|D|D_N|PADDR[3] B|Y
+ PRDATA[8]|Y A0|B2|Q|gpio_oe[2] PRDATA[2]|Y A|PCLK PRDATA[30]|Y PRDATA[20]|Y
+ A|PADDR[4] A1|PWDATA[2] PRDATA[26]|Y PRDATA[22]|Y PRDATA[24]|Y PRDATA[25]|Y
+ PRDATA[14]|Y A|A0|Q|gpio_oe[4] PRDATA[4]|Y PRDATA[11]|Y A0|B2|Q|gpio_oe[7]
+ A1|PWDATA[4] A0|A1|Q|gpio_out[4] A0|B2|Q|gpio_oe[5] A0|C1|Q|gpio_out[7]
+ A1|PWDATA[7] A0|C1|Q|gpio_out[5] A1|PWDATA[5] A1|gpio_in[7] A2|B1|Y
+ A1|gpio_in[5] B2|gpio_in[4] PRDATA[7]|Y PRDATA[5]|Y
+ LO|PRDATA[10]|PRDATA[12]|PRDATA[13]|PRDATA[15]|PRDATA[16]|PRDATA[17]|PRDATA[18]|PRDATA[19]|PRDATA[21]|PRDATA[23]|PRDATA[27]|PRDATA[28]|PRDATA[29]|PRDATA[31]|PRDATA[9]|PSLVERR|VGND
M$1 HI|VPB|VPWR S|X \$74 HI|VPB|VPWR sky130_fd_pr__pfet_01v8_hvt L=0.15 W=0.42
+ AS=0.15835 AD=0.07665 PS=1.395 PD=0.785
M$2 \$74 A0|B2|Q|gpio_oe[0] \$32 HI|VPB|VPWR sky130_fd_pr__pfet_01v8_hvt L=0.15
+ W=0.42 AS=0.07665 AD=0.1932 PS=0.785 PD=1.34
M$3 \$32 A1|PWDATA[0] \$75 HI|VPB|VPWR sky130_fd_pr__pfet_01v8_hvt L=0.15
+ W=0.42 AS=0.1932 AD=0.0441 PS=1.34 PD=0.63
M$4 \$75 \$35 HI|VPB|VPWR HI|VPB|VPWR sky130_fd_pr__pfet_01v8_hvt L=0.15 W=0.42
+ AS=0.0441 AD=0.0693 PS=0.63 PD=0.75
M$5 HI|VPB|VPWR S|X \$35 HI|VPB|VPWR sky130_fd_pr__pfet_01v8_hvt L=0.15 W=0.42
+ AS=0.0693 AD=0.1176 PS=0.75 PD=1.4
M$6 A|X \$32 HI|VPB|VPWR HI|VPB|VPWR sky130_fd_pr__pfet_01v8_hvt L=0.15 W=1
+ AS=0.26 AD=0.15835 PS=2.52 PD=1.395
M$7 HI|VPB|VPWR A|X \$40 HI|VPB|VPWR sky130_fd_pr__pfet_01v8_hvt L=0.15 W=2
+ AS=0.395 AD=0.27 PS=3.79 PD=2.54
M$9 HI|VPB|VPWR \$40 D|X HI|VPB|VPWR sky130_fd_pr__pfet_01v8_hvt L=0.15 W=6
+ AS=0.81 AD=0.935 PS=7.62 PD=8.87
M$15 HI|VPB|VPWR D|X \$81 HI|VPB|VPWR sky130_fd_pr__pfet_01v8_hvt L=0.15 W=0.42
+ AS=0.1092 AD=0.0651 PS=1.36 PD=0.73
M$16 \$81 \$80 \$82 HI|VPB|VPWR sky130_fd_pr__pfet_01v8_hvt L=0.15 W=0.42
+ AS=0.0651 AD=0.07245 PS=0.73 PD=0.765
M$17 \$82 \$79 \$83 HI|VPB|VPWR sky130_fd_pr__pfet_01v8_hvt L=0.15 W=0.42
+ AS=0.07245 AD=0.1155 PS=0.765 PD=0.97
M$18 \$83 \$105 HI|VPB|VPWR HI|VPB|VPWR sky130_fd_pr__pfet_01v8_hvt L=0.15
+ W=0.42 AS=0.1155 AD=0.07035 PS=0.97 PD=0.755
M$19 HI|VPB|VPWR PRESETn|RESET_B \$83 HI|VPB|VPWR sky130_fd_pr__pfet_01v8_hvt
+ L=0.15 W=0.42 AS=0.07035 AD=0.1092 PS=0.755 PD=1.36
M$20 \$105 \$79 \$84 HI|VPB|VPWR sky130_fd_pr__pfet_01v8_hvt L=0.15 W=0.42
+ AS=0.12915 AD=0.0588 PS=1.185 PD=0.7
M$21 \$84 \$80 \$101 HI|VPB|VPWR sky130_fd_pr__pfet_01v8_hvt L=0.15 W=0.42
+ AS=0.0588 AD=0.0567 PS=0.7 PD=0.69
M$22 \$101 \$85 HI|VPB|VPWR HI|VPB|VPWR sky130_fd_pr__pfet_01v8_hvt L=0.15
+ W=0.42 AS=0.0567 AD=0.0819 PS=0.69 PD=0.81
M$23 HI|VPB|VPWR PRESETn|RESET_B \$85 HI|VPB|VPWR sky130_fd_pr__pfet_01v8_hvt
+ L=0.15 W=0.42 AS=0.0819 AD=0.0567 PS=0.81 PD=0.69
M$24 \$85 \$84 HI|VPB|VPWR HI|VPB|VPWR sky130_fd_pr__pfet_01v8_hvt L=0.15
+ W=0.42 AS=0.0567 AD=0.1134 PS=0.69 PD=1.38
M$25 HI|VPB|VPWR \$82 \$105 HI|VPB|VPWR sky130_fd_pr__pfet_01v8_hvt L=0.15
+ W=0.84 AS=0.2184 AD=0.12915 PS=2.2 PD=1.185
M$26 HI|VPB|VPWR \$85 A0|B2|Q|gpio_oe[0] HI|VPB|VPWR
+ sky130_fd_pr__pfet_01v8_hvt L=0.15 W=1 AS=0.3012 AD=0.26 PS=2.66 PD=2.52
M$27 \$86 A2|Y HI|VPB|VPWR HI|VPB|VPWR sky130_fd_pr__pfet_01v8_hvt L=0.15 W=2
+ AS=0.415 AD=0.275 PS=3.83 PD=2.55
M$28 HI|VPB|VPWR A1|Y \$86 HI|VPB|VPWR sky130_fd_pr__pfet_01v8_hvt L=0.15 W=2
+ AS=0.28 AD=0.275 PS=2.56 PD=2.55
M$31 \$86 A|B1|X PRDATA[0]|Y HI|VPB|VPWR sky130_fd_pr__pfet_01v8_hvt L=0.15 W=2
+ AS=0.27 AD=0.495 PS=2.54 PD=3.99
M$33 \$88 A2|Y HI|VPB|VPWR HI|VPB|VPWR sky130_fd_pr__pfet_01v8_hvt L=0.15 W=2
+ AS=0.415 AD=0.275 PS=3.83 PD=2.55
M$34 HI|VPB|VPWR A1|Y \$88 HI|VPB|VPWR sky130_fd_pr__pfet_01v8_hvt L=0.15 W=2
+ AS=0.28 AD=0.275 PS=2.56 PD=2.55
M$37 \$88 A|B1|X PRDATA[6]|Y HI|VPB|VPWR sky130_fd_pr__pfet_01v8_hvt L=0.15 W=2
+ AS=0.27 AD=0.495 PS=2.54 PD=3.99
M$39 HI|VPB|VPWR A1|gpio_in[6] \$78 HI|VPB|VPWR sky130_fd_pr__pfet_01v8_hvt
+ L=0.15 W=0.64 AS=0.1696 AD=0.0768 PS=1.81 PD=0.88
M$40 \$78 A|A2|C|D_N|X A1|Y HI|VPB|VPWR sky130_fd_pr__pfet_01v8_hvt L=0.15
+ W=0.64 AS=0.0768 AD=0.0896 PS=0.88 PD=0.92
M$41 A1|Y B|B1|Y HI|VPB|VPWR HI|VPB|VPWR sky130_fd_pr__pfet_01v8_hvt L=0.15
+ W=3.2 AS=0.448 AD=0.912 PS=4.6 PD=9.25
M$42 HI|VPB|VPWR A|PADDR[2] \$91 HI|VPB|VPWR sky130_fd_pr__pfet_01v8_hvt L=0.15
+ W=0.64 AS=0.149 AD=0.1664 PS=1.325 PD=1.8
M$43 HI|VPB|VPWR \$91 A|A2|C|D_N|X HI|VPB|VPWR sky130_fd_pr__pfet_01v8_hvt
+ L=0.15 W=2 AS=0.284 AD=0.4 PS=2.595 PD=3.8
M$45 HI|VPB|VPWR A1|gpio_in[1] \$115 HI|VPB|VPWR sky130_fd_pr__pfet_01v8_hvt
+ L=0.15 W=0.64 AS=0.1696 AD=0.0768 PS=1.81 PD=0.88
M$46 \$115 A|A2|C|D_N|X A1|Y HI|VPB|VPWR sky130_fd_pr__pfet_01v8_hvt L=0.15
+ W=0.64 AS=0.0768 AD=0.0896 PS=0.88 PD=0.92
M$48 \$93 A2|Y HI|VPB|VPWR HI|VPB|VPWR sky130_fd_pr__pfet_01v8_hvt L=0.15 W=2
+ AS=0.415 AD=0.275 PS=3.83 PD=2.55
M$49 HI|VPB|VPWR A1|Y \$93 HI|VPB|VPWR sky130_fd_pr__pfet_01v8_hvt L=0.15 W=2
+ AS=0.28 AD=0.275 PS=2.56 PD=2.55
M$52 \$93 A|B1|X PRDATA[1]|Y HI|VPB|VPWR sky130_fd_pr__pfet_01v8_hvt L=0.15 W=2
+ AS=0.27 AD=0.495 PS=2.54 PD=3.99
M$54 HI|VPB|VPWR D|X \$96 HI|VPB|VPWR sky130_fd_pr__pfet_01v8_hvt L=0.15 W=0.42
+ AS=0.1092 AD=0.0651 PS=1.36 PD=0.73
M$55 \$96 \$95 \$97 HI|VPB|VPWR sky130_fd_pr__pfet_01v8_hvt L=0.15 W=0.42
+ AS=0.0651 AD=0.07245 PS=0.73 PD=0.765
M$56 \$97 \$94 \$98 HI|VPB|VPWR sky130_fd_pr__pfet_01v8_hvt L=0.15 W=0.42
+ AS=0.07245 AD=0.1155 PS=0.765 PD=0.97
M$57 \$98 \$113 HI|VPB|VPWR HI|VPB|VPWR sky130_fd_pr__pfet_01v8_hvt L=0.15
+ W=0.42 AS=0.1155 AD=0.07035 PS=0.97 PD=0.755
M$58 HI|VPB|VPWR PRESETn|RESET_B \$98 HI|VPB|VPWR sky130_fd_pr__pfet_01v8_hvt
+ L=0.15 W=0.42 AS=0.07035 AD=0.1092 PS=0.755 PD=1.36
M$59 \$113 \$94 \$99 HI|VPB|VPWR sky130_fd_pr__pfet_01v8_hvt L=0.15 W=0.42
+ AS=0.12915 AD=0.0588 PS=1.185 PD=0.7
M$60 \$99 \$95 \$102 HI|VPB|VPWR sky130_fd_pr__pfet_01v8_hvt L=0.15 W=0.42
+ AS=0.0588 AD=0.0567 PS=0.7 PD=0.69
M$61 \$102 \$100 HI|VPB|VPWR HI|VPB|VPWR sky130_fd_pr__pfet_01v8_hvt L=0.15
+ W=0.42 AS=0.0567 AD=0.0819 PS=0.69 PD=0.81
M$62 HI|VPB|VPWR PRESETn|RESET_B \$100 HI|VPB|VPWR sky130_fd_pr__pfet_01v8_hvt
+ L=0.15 W=0.42 AS=0.0819 AD=0.0567 PS=0.81 PD=0.69
M$63 \$100 \$99 HI|VPB|VPWR HI|VPB|VPWR sky130_fd_pr__pfet_01v8_hvt L=0.15
+ W=0.42 AS=0.0567 AD=0.1134 PS=0.69 PD=1.38
M$64 HI|VPB|VPWR \$97 \$113 HI|VPB|VPWR sky130_fd_pr__pfet_01v8_hvt L=0.15
+ W=0.84 AS=0.2184 AD=0.12915 PS=2.2 PD=1.185
M$65 HI|VPB|VPWR \$100 A0|B2|Q|gpio_oe[3] HI|VPB|VPWR
+ sky130_fd_pr__pfet_01v8_hvt L=0.15 W=1 AS=0.3012 AD=0.26 PS=2.66 PD=2.52
M$66 \$79 CLK|X HI|VPB|VPWR HI|VPB|VPWR sky130_fd_pr__pfet_01v8_hvt L=0.15
+ W=0.64 AS=0.1664 AD=0.0864 PS=1.8 PD=0.91
M$67 HI|VPB|VPWR \$79 \$80 HI|VPB|VPWR sky130_fd_pr__pfet_01v8_hvt L=0.15
+ W=0.64 AS=0.0864 AD=0.1664 PS=0.91 PD=1.8
M$68 \$134 CLK|X HI|VPB|VPWR HI|VPB|VPWR sky130_fd_pr__pfet_01v8_hvt L=0.15
+ W=0.64 AS=0.1664 AD=0.0864 PS=1.8 PD=0.91
M$69 HI|VPB|VPWR \$134 \$135 HI|VPB|VPWR sky130_fd_pr__pfet_01v8_hvt L=0.15
+ W=0.64 AS=0.0864 AD=0.1664 PS=0.91 PD=1.8
M$70 HI|VPB|VPWR D|X \$136 HI|VPB|VPWR sky130_fd_pr__pfet_01v8_hvt L=0.15
+ W=0.42 AS=0.1092 AD=0.0651 PS=1.36 PD=0.73
M$71 \$136 \$135 \$137 HI|VPB|VPWR sky130_fd_pr__pfet_01v8_hvt L=0.15 W=0.42
+ AS=0.0651 AD=0.07245 PS=0.73 PD=0.765
M$72 \$137 \$134 \$211 HI|VPB|VPWR sky130_fd_pr__pfet_01v8_hvt L=0.15 W=0.42
+ AS=0.07245 AD=0.1155 PS=0.765 PD=0.97
M$73 \$211 \$209 HI|VPB|VPWR HI|VPB|VPWR sky130_fd_pr__pfet_01v8_hvt L=0.15
+ W=0.42 AS=0.1155 AD=0.07035 PS=0.97 PD=0.755
M$74 HI|VPB|VPWR PRESETn|RESET_B \$211 HI|VPB|VPWR sky130_fd_pr__pfet_01v8_hvt
+ L=0.15 W=0.42 AS=0.07035 AD=0.1092 PS=0.755 PD=1.36
M$75 HI|VPB|VPWR \$137 \$209 HI|VPB|VPWR sky130_fd_pr__pfet_01v8_hvt L=0.15
+ W=0.84 AS=0.2184 AD=0.12915 PS=2.2 PD=1.185
M$76 \$209 \$134 \$138 HI|VPB|VPWR sky130_fd_pr__pfet_01v8_hvt L=0.15 W=0.42
+ AS=0.12915 AD=0.0588 PS=1.185 PD=0.7
M$77 \$138 \$135 \$218 HI|VPB|VPWR sky130_fd_pr__pfet_01v8_hvt L=0.15 W=0.42
+ AS=0.0588 AD=0.0567 PS=0.7 PD=0.69
M$78 \$218 \$139 HI|VPB|VPWR HI|VPB|VPWR sky130_fd_pr__pfet_01v8_hvt L=0.15
+ W=0.42 AS=0.0567 AD=0.0819 PS=0.69 PD=0.81
M$79 HI|VPB|VPWR PRESETn|RESET_B \$139 HI|VPB|VPWR sky130_fd_pr__pfet_01v8_hvt
+ L=0.15 W=0.42 AS=0.0819 AD=0.0567 PS=0.81 PD=0.69
M$80 \$139 \$138 HI|VPB|VPWR HI|VPB|VPWR sky130_fd_pr__pfet_01v8_hvt L=0.15
+ W=0.42 AS=0.0567 AD=0.1134 PS=0.69 PD=1.38
M$81 HI|VPB|VPWR \$139 A0|A1|Q|gpio_out[0] HI|VPB|VPWR
+ sky130_fd_pr__pfet_01v8_hvt L=0.15 W=1 AS=0.3012 AD=0.26 PS=2.66 PD=2.52
M$82 A2|Y A0|B2|Q|gpio_oe[0] \$212 HI|VPB|VPWR sky130_fd_pr__pfet_01v8_hvt
+ L=0.15 W=1 AS=0.26 AD=0.135 PS=2.52 PD=1.27
M$83 \$212 B|B1|B_N|Y A2|Y HI|VPB|VPWR sky130_fd_pr__pfet_01v8_hvt L=0.15 W=1
+ AS=0.135 AD=0.26 PS=1.27 PD=2.52
M$84 HI|VPB|VPWR A0|A1|Q|gpio_out[0] \$212 HI|VPB|VPWR
+ sky130_fd_pr__pfet_01v8_hvt L=0.15 W=1 AS=0.26 AD=0.135 PS=2.52 PD=1.27
M$85 \$212 A2|B|C2|Y HI|VPB|VPWR HI|VPB|VPWR sky130_fd_pr__pfet_01v8_hvt L=0.15
+ W=1 AS=0.135 AD=0.3 PS=1.27 PD=2.6
M$86 HI|VPB|VPWR A1|gpio_in[0] \$220 HI|VPB|VPWR sky130_fd_pr__pfet_01v8_hvt
+ L=0.15 W=0.64 AS=0.1696 AD=0.0768 PS=1.81 PD=0.88
M$87 \$220 A|A2|C|D_N|X A1|Y HI|VPB|VPWR sky130_fd_pr__pfet_01v8_hvt L=0.15
+ W=0.64 AS=0.0768 AD=0.0896 PS=0.88 PD=0.92
M$89 HI|VPB|VPWR S|X \$221 HI|VPB|VPWR sky130_fd_pr__pfet_01v8_hvt L=0.15
+ W=0.42 AS=0.15835 AD=0.07665 PS=1.395 PD=0.785
M$90 \$221 A0|B2|Q|gpio_oe[1] \$142 HI|VPB|VPWR sky130_fd_pr__pfet_01v8_hvt
+ L=0.15 W=0.42 AS=0.07665 AD=0.1932 PS=0.785 PD=1.34
M$91 \$142 A1|PWDATA[1] \$222 HI|VPB|VPWR sky130_fd_pr__pfet_01v8_hvt L=0.15
+ W=0.42 AS=0.1932 AD=0.0441 PS=1.34 PD=0.63
M$92 \$222 \$144 HI|VPB|VPWR HI|VPB|VPWR sky130_fd_pr__pfet_01v8_hvt L=0.15
+ W=0.42 AS=0.0441 AD=0.0693 PS=0.63 PD=0.75
M$93 HI|VPB|VPWR S|X \$144 HI|VPB|VPWR sky130_fd_pr__pfet_01v8_hvt L=0.15
+ W=0.42 AS=0.0693 AD=0.1176 PS=0.75 PD=1.4
M$94 A|X \$142 HI|VPB|VPWR HI|VPB|VPWR sky130_fd_pr__pfet_01v8_hvt L=0.15 W=1
+ AS=0.26 AD=0.15835 PS=2.52 PD=1.395
M$95 A2|Y A0|B2|Q|gpio_oe[1] \$214 HI|VPB|VPWR sky130_fd_pr__pfet_01v8_hvt
+ L=0.15 W=1 AS=0.26 AD=0.135 PS=2.52 PD=1.27
M$96 \$214 B|B1|B_N|Y A2|Y HI|VPB|VPWR sky130_fd_pr__pfet_01v8_hvt L=0.15 W=1
+ AS=0.135 AD=0.26 PS=1.27 PD=2.52
M$97 HI|VPB|VPWR A0|A1|Q|gpio_out[1] \$214 HI|VPB|VPWR
+ sky130_fd_pr__pfet_01v8_hvt L=0.15 W=1 AS=0.26 AD=0.135 PS=2.52 PD=1.27
M$98 \$214 A2|B|C2|Y HI|VPB|VPWR HI|VPB|VPWR sky130_fd_pr__pfet_01v8_hvt L=0.15
+ W=1 AS=0.135 AD=0.3 PS=1.27 PD=2.6
M$99 \$94 CLK|X HI|VPB|VPWR HI|VPB|VPWR sky130_fd_pr__pfet_01v8_hvt L=0.15
+ W=0.64 AS=0.1664 AD=0.0864 PS=1.8 PD=0.91
M$100 HI|VPB|VPWR \$94 \$95 HI|VPB|VPWR sky130_fd_pr__pfet_01v8_hvt L=0.15
+ W=0.64 AS=0.0864 AD=0.1664 PS=0.91 PD=1.8
M$101 \$146 CLK|X HI|VPB|VPWR HI|VPB|VPWR sky130_fd_pr__pfet_01v8_hvt L=0.15
+ W=0.64 AS=0.1664 AD=0.0864 PS=1.8 PD=0.91
M$102 HI|VPB|VPWR \$146 \$147 HI|VPB|VPWR sky130_fd_pr__pfet_01v8_hvt L=0.15
+ W=0.64 AS=0.0864 AD=0.1664 PS=0.91 PD=1.8
M$103 HI|VPB|VPWR D|X \$148 HI|VPB|VPWR sky130_fd_pr__pfet_01v8_hvt L=0.15
+ W=0.42 AS=0.1092 AD=0.0651 PS=1.36 PD=0.73
M$104 \$148 \$147 \$149 HI|VPB|VPWR sky130_fd_pr__pfet_01v8_hvt L=0.15 W=0.42
+ AS=0.0651 AD=0.07245 PS=0.73 PD=0.765
M$105 \$149 \$146 \$215 HI|VPB|VPWR sky130_fd_pr__pfet_01v8_hvt L=0.15 W=0.42
+ AS=0.07245 AD=0.1155 PS=0.765 PD=0.97
M$106 \$215 \$210 HI|VPB|VPWR HI|VPB|VPWR sky130_fd_pr__pfet_01v8_hvt L=0.15
+ W=0.42 AS=0.1155 AD=0.07035 PS=0.97 PD=0.755
M$107 HI|VPB|VPWR PRESETn|RESET_B \$215 HI|VPB|VPWR sky130_fd_pr__pfet_01v8_hvt
+ L=0.15 W=0.42 AS=0.07035 AD=0.1092 PS=0.755 PD=1.36
M$108 HI|VPB|VPWR \$149 \$210 HI|VPB|VPWR sky130_fd_pr__pfet_01v8_hvt L=0.15
+ W=0.84 AS=0.2184 AD=0.12915 PS=2.2 PD=1.185
M$109 \$210 \$146 \$150 HI|VPB|VPWR sky130_fd_pr__pfet_01v8_hvt L=0.15 W=0.42
+ AS=0.12915 AD=0.0588 PS=1.185 PD=0.7
M$110 \$150 \$147 \$217 HI|VPB|VPWR sky130_fd_pr__pfet_01v8_hvt L=0.15 W=0.42
+ AS=0.0588 AD=0.0567 PS=0.7 PD=0.69
M$111 \$217 \$151 HI|VPB|VPWR HI|VPB|VPWR sky130_fd_pr__pfet_01v8_hvt L=0.15
+ W=0.42 AS=0.0567 AD=0.0819 PS=0.69 PD=0.81
M$112 HI|VPB|VPWR PRESETn|RESET_B \$151 HI|VPB|VPWR sky130_fd_pr__pfet_01v8_hvt
+ L=0.15 W=0.42 AS=0.0819 AD=0.0567 PS=0.81 PD=0.69
M$113 \$151 \$150 HI|VPB|VPWR HI|VPB|VPWR sky130_fd_pr__pfet_01v8_hvt L=0.15
+ W=0.42 AS=0.0567 AD=0.1134 PS=0.69 PD=1.38
M$114 HI|VPB|VPWR \$151 A0|A1|Q|gpio_out[3] HI|VPB|VPWR
+ sky130_fd_pr__pfet_01v8_hvt L=0.15 W=1 AS=0.3012 AD=0.26 PS=2.66 PD=2.52
M$115 \$223 A|X HI|VPB|VPWR HI|VPB|VPWR sky130_fd_pr__pfet_01v8_hvt L=0.15 W=1
+ AS=0.26 AD=0.135 PS=2.52 PD=1.27
M$116 HI|VPB|VPWR \$223 D|X HI|VPB|VPWR sky130_fd_pr__pfet_01v8_hvt L=0.15 W=4
+ AS=0.54 AD=0.665 PS=5.08 PD=6.33
M$120 \$224 S|X HI|VPB|VPWR HI|VPB|VPWR sky130_fd_pr__pfet_01v8_hvt L=0.15 W=1
+ AS=0.26 AD=0.1625 PS=2.52 PD=1.325
M$121 HI|VPB|VPWR \$224 \$225 HI|VPB|VPWR sky130_fd_pr__pfet_01v8_hvt L=0.15
+ W=1 AS=0.1625 AD=0.28 PS=1.325 PD=2.56
M$122 \$226 A0|A1|Q|gpio_out[0] \$227 HI|VPB|VPWR sky130_fd_pr__pfet_01v8_hvt
+ L=0.15 W=1 AS=0.26 AD=0.16 PS=2.52 PD=1.32
M$123 \$227 A1|PWDATA[0] \$225 HI|VPB|VPWR sky130_fd_pr__pfet_01v8_hvt L=0.15
+ W=1 AS=0.16 AD=0.3 PS=1.32 PD=2.6
M$124 \$226 S|X HI|VPB|VPWR HI|VPB|VPWR sky130_fd_pr__pfet_01v8_hvt L=0.15 W=1
+ AS=0.26 AD=0.135 PS=2.52 PD=1.27
M$125 HI|VPB|VPWR \$227 A|X HI|VPB|VPWR sky130_fd_pr__pfet_01v8_hvt L=0.15 W=4
+ AS=0.54 AD=0.665 PS=5.08 PD=6.33
M$129 \$229 CLK|X HI|VPB|VPWR HI|VPB|VPWR sky130_fd_pr__pfet_01v8_hvt L=0.15
+ W=0.64 AS=0.1664 AD=0.0864 PS=1.8 PD=0.91
M$130 HI|VPB|VPWR \$229 \$230 HI|VPB|VPWR sky130_fd_pr__pfet_01v8_hvt L=0.15
+ W=0.64 AS=0.0864 AD=0.1664 PS=0.91 PD=1.8
M$131 HI|VPB|VPWR D|X \$232 HI|VPB|VPWR sky130_fd_pr__pfet_01v8_hvt L=0.15
+ W=0.42 AS=0.1092 AD=0.0651 PS=1.36 PD=0.73
M$132 \$232 \$230 \$233 HI|VPB|VPWR sky130_fd_pr__pfet_01v8_hvt L=0.15 W=0.42
+ AS=0.0651 AD=0.07245 PS=0.73 PD=0.765
M$133 \$233 \$229 \$234 HI|VPB|VPWR sky130_fd_pr__pfet_01v8_hvt L=0.15 W=0.42
+ AS=0.07245 AD=0.1155 PS=0.765 PD=0.97
M$134 \$234 \$235 HI|VPB|VPWR HI|VPB|VPWR sky130_fd_pr__pfet_01v8_hvt L=0.15
+ W=0.42 AS=0.1155 AD=0.07035 PS=0.97 PD=0.755
M$135 HI|VPB|VPWR PRESETn|RESET_B \$234 HI|VPB|VPWR sky130_fd_pr__pfet_01v8_hvt
+ L=0.15 W=0.42 AS=0.07035 AD=0.1092 PS=0.755 PD=1.36
M$136 \$235 \$229 \$236 HI|VPB|VPWR sky130_fd_pr__pfet_01v8_hvt L=0.15 W=0.42
+ AS=0.12915 AD=0.0588 PS=1.185 PD=0.7
M$137 \$236 \$230 \$245 HI|VPB|VPWR sky130_fd_pr__pfet_01v8_hvt L=0.15 W=0.42
+ AS=0.0588 AD=0.0567 PS=0.7 PD=0.69
M$138 \$245 \$237 HI|VPB|VPWR HI|VPB|VPWR sky130_fd_pr__pfet_01v8_hvt L=0.15
+ W=0.42 AS=0.0567 AD=0.0819 PS=0.69 PD=0.81
M$139 HI|VPB|VPWR PRESETn|RESET_B \$237 HI|VPB|VPWR sky130_fd_pr__pfet_01v8_hvt
+ L=0.15 W=0.42 AS=0.0819 AD=0.0567 PS=0.81 PD=0.69
M$140 \$237 \$236 HI|VPB|VPWR HI|VPB|VPWR sky130_fd_pr__pfet_01v8_hvt L=0.15
+ W=0.42 AS=0.0567 AD=0.1134 PS=0.69 PD=1.38
M$141 HI|VPB|VPWR \$233 \$235 HI|VPB|VPWR sky130_fd_pr__pfet_01v8_hvt L=0.15
+ W=0.84 AS=0.2184 AD=0.12915 PS=2.2 PD=1.185
M$142 HI|VPB|VPWR \$237 A0|B2|Q|gpio_oe[1] HI|VPB|VPWR
+ sky130_fd_pr__pfet_01v8_hvt L=0.15 W=1 AS=0.3012 AD=0.26 PS=2.66 PD=2.52
M$143 \$238 A|X HI|VPB|VPWR HI|VPB|VPWR sky130_fd_pr__pfet_01v8_hvt L=0.15 W=1
+ AS=0.26 AD=0.135 PS=2.52 PD=1.27
M$144 HI|VPB|VPWR \$238 D|X HI|VPB|VPWR sky130_fd_pr__pfet_01v8_hvt L=0.15 W=4
+ AS=0.54 AD=0.665 PS=5.08 PD=6.33
M$148 \$239 S|X HI|VPB|VPWR HI|VPB|VPWR sky130_fd_pr__pfet_01v8_hvt L=0.15 W=1
+ AS=0.26 AD=0.1625 PS=2.52 PD=1.325
M$149 HI|VPB|VPWR \$239 \$240 HI|VPB|VPWR sky130_fd_pr__pfet_01v8_hvt L=0.15
+ W=1 AS=0.1625 AD=0.28 PS=1.325 PD=2.56
M$150 \$241 A0|A1|Q|gpio_out[3] \$242 HI|VPB|VPWR sky130_fd_pr__pfet_01v8_hvt
+ L=0.15 W=1 AS=0.26 AD=0.16 PS=2.52 PD=1.32
M$151 \$242 A1|PWDATA[3] \$240 HI|VPB|VPWR sky130_fd_pr__pfet_01v8_hvt L=0.15
+ W=1 AS=0.16 AD=0.3 PS=1.32 PD=2.6
M$152 \$241 S|X HI|VPB|VPWR HI|VPB|VPWR sky130_fd_pr__pfet_01v8_hvt L=0.15 W=1
+ AS=0.26 AD=0.135 PS=2.52 PD=1.27
M$153 HI|VPB|VPWR \$242 A|X HI|VPB|VPWR sky130_fd_pr__pfet_01v8_hvt L=0.15 W=4
+ AS=0.54 AD=0.665 PS=5.08 PD=6.33
M$157 A2|Y A0|B2|Q|gpio_oe[3] \$244 HI|VPB|VPWR sky130_fd_pr__pfet_01v8_hvt
+ L=0.15 W=1 AS=0.26 AD=0.135 PS=2.52 PD=1.27
M$158 \$244 B|B1|B_N|Y A2|Y HI|VPB|VPWR sky130_fd_pr__pfet_01v8_hvt L=0.15 W=1
+ AS=0.135 AD=0.26 PS=1.27 PD=2.52
M$159 HI|VPB|VPWR A0|A1|Q|gpio_out[3] \$244 HI|VPB|VPWR
+ sky130_fd_pr__pfet_01v8_hvt L=0.15 W=1 AS=0.26 AD=0.135 PS=2.52 PD=1.27
M$160 \$244 A2|B|C2|Y HI|VPB|VPWR HI|VPB|VPWR sky130_fd_pr__pfet_01v8_hvt
+ L=0.15 W=1 AS=0.135 AD=0.3 PS=1.27 PD=2.6
M$161 HI|VPB|VPWR S|X \$331 HI|VPB|VPWR sky130_fd_pr__pfet_01v8_hvt L=0.15
+ W=0.42 AS=0.15835 AD=0.07665 PS=1.395 PD=0.785
M$162 \$331 A0|B2|Q|gpio_oe[6] \$262 HI|VPB|VPWR sky130_fd_pr__pfet_01v8_hvt
+ L=0.15 W=0.42 AS=0.07665 AD=0.1932 PS=0.785 PD=1.34
M$163 \$262 A1|PWDATA[6] \$332 HI|VPB|VPWR sky130_fd_pr__pfet_01v8_hvt L=0.15
+ W=0.42 AS=0.1932 AD=0.0441 PS=1.34 PD=0.63
M$164 \$332 \$264 HI|VPB|VPWR HI|VPB|VPWR sky130_fd_pr__pfet_01v8_hvt L=0.15
+ W=0.42 AS=0.0441 AD=0.0693 PS=0.63 PD=0.75
M$165 HI|VPB|VPWR S|X \$264 HI|VPB|VPWR sky130_fd_pr__pfet_01v8_hvt L=0.15
+ W=0.42 AS=0.0693 AD=0.1176 PS=0.75 PD=1.4
M$166 A|X \$262 HI|VPB|VPWR HI|VPB|VPWR sky130_fd_pr__pfet_01v8_hvt L=0.15 W=1
+ AS=0.26 AD=0.15835 PS=2.52 PD=1.395
M$167 HI|VPB|VPWR D|X \$338 HI|VPB|VPWR sky130_fd_pr__pfet_01v8_hvt L=0.15
+ W=0.42 AS=0.1092 AD=0.0651 PS=1.36 PD=0.73
M$168 \$338 \$336 \$339 HI|VPB|VPWR sky130_fd_pr__pfet_01v8_hvt L=0.15 W=0.42
+ AS=0.0651 AD=0.07245 PS=0.73 PD=0.765
M$169 \$339 \$335 \$340 HI|VPB|VPWR sky130_fd_pr__pfet_01v8_hvt L=0.15 W=0.42
+ AS=0.07245 AD=0.1155 PS=0.765 PD=0.97
M$170 \$340 \$341 HI|VPB|VPWR HI|VPB|VPWR sky130_fd_pr__pfet_01v8_hvt L=0.15
+ W=0.42 AS=0.1155 AD=0.07035 PS=0.97 PD=0.755
M$171 HI|VPB|VPWR PRESETn|RESET_B \$340 HI|VPB|VPWR sky130_fd_pr__pfet_01v8_hvt
+ L=0.15 W=0.42 AS=0.07035 AD=0.1092 PS=0.755 PD=1.36
M$172 HI|VPB|VPWR A|X \$265 HI|VPB|VPWR sky130_fd_pr__pfet_01v8_hvt L=0.15 W=2
+ AS=0.395 AD=0.27 PS=3.79 PD=2.54
M$174 HI|VPB|VPWR \$265 D|X HI|VPB|VPWR sky130_fd_pr__pfet_01v8_hvt L=0.15 W=6
+ AS=0.81 AD=0.935 PS=7.62 PD=8.87
M$180 \$341 \$335 \$342 HI|VPB|VPWR sky130_fd_pr__pfet_01v8_hvt L=0.15 W=0.42
+ AS=0.12915 AD=0.0588 PS=1.185 PD=0.7
M$181 \$342 \$336 \$349 HI|VPB|VPWR sky130_fd_pr__pfet_01v8_hvt L=0.15 W=0.42
+ AS=0.0588 AD=0.0567 PS=0.7 PD=0.69
M$182 \$349 \$343 HI|VPB|VPWR HI|VPB|VPWR sky130_fd_pr__pfet_01v8_hvt L=0.15
+ W=0.42 AS=0.0567 AD=0.0819 PS=0.69 PD=0.81
M$183 HI|VPB|VPWR PRESETn|RESET_B \$343 HI|VPB|VPWR sky130_fd_pr__pfet_01v8_hvt
+ L=0.15 W=0.42 AS=0.0819 AD=0.0567 PS=0.81 PD=0.69
M$184 \$343 \$342 HI|VPB|VPWR HI|VPB|VPWR sky130_fd_pr__pfet_01v8_hvt L=0.15
+ W=0.42 AS=0.0567 AD=0.1134 PS=0.69 PD=1.38
M$185 HI|VPB|VPWR \$339 \$341 HI|VPB|VPWR sky130_fd_pr__pfet_01v8_hvt L=0.15
+ W=0.84 AS=0.2184 AD=0.12915 PS=2.2 PD=1.185
M$186 HI|VPB|VPWR \$343 A0|B2|Q|gpio_oe[6] HI|VPB|VPWR
+ sky130_fd_pr__pfet_01v8_hvt L=0.15 W=1 AS=0.3012 AD=0.26 PS=2.66 PD=2.52
M$187 HI|VPB|VPWR A|X \$344 HI|VPB|VPWR sky130_fd_pr__pfet_01v8_hvt L=0.15 W=4
+ AS=0.685 AD=0.56 PS=6.37 PD=5.12
M$191 HI|VPB|VPWR \$344 CLK|X HI|VPB|VPWR sky130_fd_pr__pfet_01v8_hvt L=0.15
+ W=16 AS=2.2375 AD=2.3625 PS=20.475 PD=21.725
M$207 \$266 A|X HI|VPB|VPWR HI|VPB|VPWR sky130_fd_pr__pfet_01v8_hvt L=0.15 W=1
+ AS=0.26 AD=0.135 PS=2.52 PD=1.27
M$208 HI|VPB|VPWR \$266 D|X HI|VPB|VPWR sky130_fd_pr__pfet_01v8_hvt L=0.15 W=4
+ AS=0.54 AD=0.665 PS=5.08 PD=6.33
M$212 \$267 CLK|X HI|VPB|VPWR HI|VPB|VPWR sky130_fd_pr__pfet_01v8_hvt L=0.15
+ W=0.64 AS=0.1664 AD=0.0864 PS=1.8 PD=0.91
M$213 HI|VPB|VPWR \$267 \$268 HI|VPB|VPWR sky130_fd_pr__pfet_01v8_hvt L=0.15
+ W=0.64 AS=0.0864 AD=0.1664 PS=0.91 PD=1.8
M$214 HI|VPB|VPWR D|X \$269 HI|VPB|VPWR sky130_fd_pr__pfet_01v8_hvt L=0.15
+ W=0.42 AS=0.1092 AD=0.0651 PS=1.36 PD=0.73
M$215 \$269 \$268 \$270 HI|VPB|VPWR sky130_fd_pr__pfet_01v8_hvt L=0.15 W=0.42
+ AS=0.0651 AD=0.07245 PS=0.73 PD=0.765
M$216 \$270 \$267 \$327 HI|VPB|VPWR sky130_fd_pr__pfet_01v8_hvt L=0.15 W=0.42
+ AS=0.07245 AD=0.1155 PS=0.765 PD=0.97
M$217 \$327 \$326 HI|VPB|VPWR HI|VPB|VPWR sky130_fd_pr__pfet_01v8_hvt L=0.15
+ W=0.42 AS=0.1155 AD=0.07035 PS=0.97 PD=0.755
M$218 HI|VPB|VPWR PRESETn|RESET_B \$327 HI|VPB|VPWR sky130_fd_pr__pfet_01v8_hvt
+ L=0.15 W=0.42 AS=0.07035 AD=0.1092 PS=0.755 PD=1.36
M$219 HI|VPB|VPWR \$270 \$326 HI|VPB|VPWR sky130_fd_pr__pfet_01v8_hvt L=0.15
+ W=0.84 AS=0.2184 AD=0.12915 PS=2.2 PD=1.185
M$220 \$326 \$267 \$271 HI|VPB|VPWR sky130_fd_pr__pfet_01v8_hvt L=0.15 W=0.42
+ AS=0.12915 AD=0.0588 PS=1.185 PD=0.7
M$221 \$271 \$268 \$333 HI|VPB|VPWR sky130_fd_pr__pfet_01v8_hvt L=0.15 W=0.42
+ AS=0.0588 AD=0.0567 PS=0.7 PD=0.69
M$222 \$333 \$272 HI|VPB|VPWR HI|VPB|VPWR sky130_fd_pr__pfet_01v8_hvt L=0.15
+ W=0.42 AS=0.0567 AD=0.0819 PS=0.69 PD=0.81
M$223 HI|VPB|VPWR PRESETn|RESET_B \$272 HI|VPB|VPWR sky130_fd_pr__pfet_01v8_hvt
+ L=0.15 W=0.42 AS=0.0819 AD=0.0567 PS=0.81 PD=0.69
M$224 \$272 \$271 HI|VPB|VPWR HI|VPB|VPWR sky130_fd_pr__pfet_01v8_hvt L=0.15
+ W=0.42 AS=0.0567 AD=0.1134 PS=0.69 PD=1.38
M$225 HI|VPB|VPWR \$272 A0|A1|Q|gpio_out[1] HI|VPB|VPWR
+ sky130_fd_pr__pfet_01v8_hvt L=0.15 W=1 AS=0.3012 AD=0.26 PS=2.66 PD=2.52
M$226 HI|VPB|VPWR S|X \$330 HI|VPB|VPWR sky130_fd_pr__pfet_01v8_hvt L=0.15
+ W=0.42 AS=0.15835 AD=0.07665 PS=1.395 PD=0.785
M$227 \$330 A0|B2|Q|gpio_oe[3] \$273 HI|VPB|VPWR sky130_fd_pr__pfet_01v8_hvt
+ L=0.15 W=0.42 AS=0.07665 AD=0.1932 PS=0.785 PD=1.34
M$228 \$273 A1|PWDATA[3] \$329 HI|VPB|VPWR sky130_fd_pr__pfet_01v8_hvt L=0.15
+ W=0.42 AS=0.1932 AD=0.0441 PS=1.34 PD=0.63
M$229 \$329 \$274 HI|VPB|VPWR HI|VPB|VPWR sky130_fd_pr__pfet_01v8_hvt L=0.15
+ W=0.42 AS=0.0441 AD=0.0693 PS=0.63 PD=0.75
M$230 HI|VPB|VPWR S|X \$274 HI|VPB|VPWR sky130_fd_pr__pfet_01v8_hvt L=0.15
+ W=0.42 AS=0.0693 AD=0.1176 PS=0.75 PD=1.4
M$231 A|X \$273 HI|VPB|VPWR HI|VPB|VPWR sky130_fd_pr__pfet_01v8_hvt L=0.15 W=1
+ AS=0.26 AD=0.15835 PS=2.52 PD=1.395
M$232 HI|VPB|VPWR A1|gpio_in[3] \$351 HI|VPB|VPWR sky130_fd_pr__pfet_01v8_hvt
+ L=0.15 W=0.64 AS=0.1696 AD=0.0768 PS=1.81 PD=0.88
M$233 \$351 A|A2|C|D_N|X A1|Y HI|VPB|VPWR sky130_fd_pr__pfet_01v8_hvt L=0.15
+ W=0.64 AS=0.0768 AD=0.0896 PS=0.88 PD=0.92
M$235 \$346 A2|Y HI|VPB|VPWR HI|VPB|VPWR sky130_fd_pr__pfet_01v8_hvt L=0.15 W=2
+ AS=0.415 AD=0.275 PS=3.83 PD=2.55
M$236 HI|VPB|VPWR A1|Y \$346 HI|VPB|VPWR sky130_fd_pr__pfet_01v8_hvt L=0.15 W=2
+ AS=0.28 AD=0.275 PS=2.56 PD=2.55
M$239 \$346 A|B1|X PRDATA[3]|Y HI|VPB|VPWR sky130_fd_pr__pfet_01v8_hvt L=0.15
+ W=2 AS=0.27 AD=0.495 PS=2.54 PD=3.99
M$241 HI|VPB|VPWR A|X \$360 HI|VPB|VPWR sky130_fd_pr__pfet_01v8_hvt L=0.15 W=2
+ AS=0.395 AD=0.27 PS=3.79 PD=2.54
M$243 HI|VPB|VPWR \$360 D|X HI|VPB|VPWR sky130_fd_pr__pfet_01v8_hvt L=0.15 W=6
+ AS=0.81 AD=0.935 PS=7.62 PD=8.87
M$249 \$335 CLK|X HI|VPB|VPWR HI|VPB|VPWR sky130_fd_pr__pfet_01v8_hvt L=0.15
+ W=0.64 AS=0.1664 AD=0.0864 PS=1.8 PD=0.91
M$250 HI|VPB|VPWR \$335 \$336 HI|VPB|VPWR sky130_fd_pr__pfet_01v8_hvt L=0.15
+ W=0.64 AS=0.0864 AD=0.1664 PS=0.91 PD=1.8
M$251 HI|VPB|VPWR \$367 A0|A1|Q|gpio_out[6] HI|VPB|VPWR
+ sky130_fd_pr__pfet_01v8_hvt L=0.15 W=1 AS=0.3012 AD=0.26 PS=2.66 PD=2.52
M$252 A2|Y A0|B2|Q|gpio_oe[6] \$428 HI|VPB|VPWR sky130_fd_pr__pfet_01v8_hvt
+ L=0.15 W=1 AS=0.26 AD=0.135 PS=2.52 PD=1.27
M$253 \$428 B|B1|B_N|Y A2|Y HI|VPB|VPWR sky130_fd_pr__pfet_01v8_hvt L=0.15 W=1
+ AS=0.135 AD=0.26 PS=1.27 PD=2.52
M$254 HI|VPB|VPWR A0|A1|Q|gpio_out[6] \$428 HI|VPB|VPWR
+ sky130_fd_pr__pfet_01v8_hvt L=0.15 W=1 AS=0.26 AD=0.135 PS=2.52 PD=1.27
M$255 \$428 A2|B|C2|Y HI|VPB|VPWR HI|VPB|VPWR sky130_fd_pr__pfet_01v8_hvt
+ L=0.15 W=1 AS=0.135 AD=0.3 PS=1.27 PD=2.6
M$256 \$369 S|X HI|VPB|VPWR HI|VPB|VPWR sky130_fd_pr__pfet_01v8_hvt L=0.15 W=1
+ AS=0.26 AD=0.1625 PS=2.52 PD=1.325
M$257 HI|VPB|VPWR \$369 \$429 HI|VPB|VPWR sky130_fd_pr__pfet_01v8_hvt L=0.15
+ W=1 AS=0.1625 AD=0.28 PS=1.325 PD=2.56
M$258 \$430 A0|A1|Q|gpio_out[1] \$370 HI|VPB|VPWR sky130_fd_pr__pfet_01v8_hvt
+ L=0.15 W=1 AS=0.26 AD=0.16 PS=2.52 PD=1.32
M$259 \$370 A1|PWDATA[1] \$429 HI|VPB|VPWR sky130_fd_pr__pfet_01v8_hvt L=0.15
+ W=1 AS=0.16 AD=0.3 PS=1.32 PD=2.6
M$260 \$430 S|X HI|VPB|VPWR HI|VPB|VPWR sky130_fd_pr__pfet_01v8_hvt L=0.15 W=1
+ AS=0.26 AD=0.135 PS=2.52 PD=1.27
M$261 HI|VPB|VPWR \$370 A|X HI|VPB|VPWR sky130_fd_pr__pfet_01v8_hvt L=0.15 W=4
+ AS=0.54 AD=0.665 PS=5.08 PD=6.33
M$265 HI|VPB|VPWR A|X \$372 HI|VPB|VPWR sky130_fd_pr__pfet_01v8_hvt L=0.15 W=2
+ AS=0.395 AD=0.27 PS=3.79 PD=2.54
M$267 HI|VPB|VPWR \$372 D|X HI|VPB|VPWR sky130_fd_pr__pfet_01v8_hvt L=0.15 W=6
+ AS=0.81 AD=0.935 PS=7.62 PD=8.87
M$273 \$373 A|Y HI|VPB|VPWR HI|VPB|VPWR sky130_fd_pr__pfet_01v8_hvt L=0.15 W=1
+ AS=0.26 AD=0.135 PS=2.52 PD=1.27
M$274 HI|VPB|VPWR \$373 S|X HI|VPB|VPWR sky130_fd_pr__pfet_01v8_hvt L=0.15 W=4
+ AS=0.54 AD=0.665 PS=5.08 PD=6.33
M$278 HI|VPB|VPWR A|X \$374 HI|VPB|VPWR sky130_fd_pr__pfet_01v8_hvt L=0.15
+ W=0.64 AS=0.149 AD=0.1664 PS=1.325 PD=1.8
M$279 HI|VPB|VPWR \$374 B|PREADY|X HI|VPB|VPWR sky130_fd_pr__pfet_01v8_hvt
+ L=0.15 W=2 AS=0.284 AD=0.4 PS=2.595 PD=3.8
M$281 \$434 S|X HI|VPB|VPWR HI|VPB|VPWR sky130_fd_pr__pfet_01v8_hvt L=0.15 W=1
+ AS=0.26 AD=0.1625 PS=2.52 PD=1.325
M$282 HI|VPB|VPWR \$434 \$435 HI|VPB|VPWR sky130_fd_pr__pfet_01v8_hvt L=0.15
+ W=1 AS=0.1625 AD=0.28 PS=1.325 PD=2.56
M$283 \$436 A0|A1|Q|gpio_out[6] \$437 HI|VPB|VPWR sky130_fd_pr__pfet_01v8_hvt
+ L=0.15 W=1 AS=0.26 AD=0.16 PS=2.52 PD=1.32
M$284 \$437 A1|PWDATA[6] \$435 HI|VPB|VPWR sky130_fd_pr__pfet_01v8_hvt L=0.15
+ W=1 AS=0.16 AD=0.3 PS=1.32 PD=2.6
M$285 \$362 CLK|X HI|VPB|VPWR HI|VPB|VPWR sky130_fd_pr__pfet_01v8_hvt L=0.15
+ W=0.64 AS=0.1664 AD=0.0864 PS=1.8 PD=0.91
M$286 HI|VPB|VPWR \$362 \$363 HI|VPB|VPWR sky130_fd_pr__pfet_01v8_hvt L=0.15
+ W=0.64 AS=0.0864 AD=0.1664 PS=0.91 PD=1.8
M$287 \$436 S|X HI|VPB|VPWR HI|VPB|VPWR sky130_fd_pr__pfet_01v8_hvt L=0.15 W=1
+ AS=0.26 AD=0.135 PS=2.52 PD=1.27
M$288 HI|VPB|VPWR \$437 A|X HI|VPB|VPWR sky130_fd_pr__pfet_01v8_hvt L=0.15 W=4
+ AS=0.54 AD=0.665 PS=5.08 PD=6.33
M$292 HI|VPB|VPWR D|X \$364 HI|VPB|VPWR sky130_fd_pr__pfet_01v8_hvt L=0.15
+ W=0.42 AS=0.1092 AD=0.0651 PS=1.36 PD=0.73
M$293 \$364 \$363 \$365 HI|VPB|VPWR sky130_fd_pr__pfet_01v8_hvt L=0.15 W=0.42
+ AS=0.0651 AD=0.07245 PS=0.73 PD=0.765
M$294 \$365 \$362 \$427 HI|VPB|VPWR sky130_fd_pr__pfet_01v8_hvt L=0.15 W=0.42
+ AS=0.07245 AD=0.1155 PS=0.765 PD=0.97
M$295 \$427 \$425 HI|VPB|VPWR HI|VPB|VPWR sky130_fd_pr__pfet_01v8_hvt L=0.15
+ W=0.42 AS=0.1155 AD=0.07035 PS=0.97 PD=0.755
M$296 HI|VPB|VPWR PRESETn|RESET_B \$427 HI|VPB|VPWR sky130_fd_pr__pfet_01v8_hvt
+ L=0.15 W=0.42 AS=0.07035 AD=0.1092 PS=0.755 PD=1.36
M$297 HI|VPB|VPWR \$365 \$425 HI|VPB|VPWR sky130_fd_pr__pfet_01v8_hvt L=0.15
+ W=0.84 AS=0.2184 AD=0.12915 PS=2.2 PD=1.185
M$298 \$425 \$362 \$366 HI|VPB|VPWR sky130_fd_pr__pfet_01v8_hvt L=0.15 W=0.42
+ AS=0.12915 AD=0.0588 PS=1.185 PD=0.7
M$299 \$366 \$363 \$432 HI|VPB|VPWR sky130_fd_pr__pfet_01v8_hvt L=0.15 W=0.42
+ AS=0.0588 AD=0.0567 PS=0.7 PD=0.69
M$300 \$432 \$367 HI|VPB|VPWR HI|VPB|VPWR sky130_fd_pr__pfet_01v8_hvt L=0.15
+ W=0.42 AS=0.0567 AD=0.0819 PS=0.69 PD=0.81
M$301 HI|VPB|VPWR PRESETn|RESET_B \$367 HI|VPB|VPWR sky130_fd_pr__pfet_01v8_hvt
+ L=0.15 W=0.42 AS=0.0819 AD=0.0567 PS=0.81 PD=0.69
M$302 \$367 \$366 HI|VPB|VPWR HI|VPB|VPWR sky130_fd_pr__pfet_01v8_hvt L=0.15
+ W=0.42 AS=0.0567 AD=0.1134 PS=0.69 PD=1.38
M$303 \$438 A|A_N|Y HI|VPB|VPWR HI|VPB|VPWR sky130_fd_pr__pfet_01v8_hvt L=0.15
+ W=0.42 AS=0.1092 AD=0.0714 PS=1.36 PD=0.76
M$304 HI|VPB|VPWR \$438 \$440 HI|VPB|VPWR sky130_fd_pr__pfet_01v8_hvt L=0.15
+ W=0.42 AS=0.0714 AD=0.0609 PS=0.76 PD=0.71
M$305 \$440 A2|B|C2|Y HI|VPB|VPWR HI|VPB|VPWR sky130_fd_pr__pfet_01v8_hvt
+ L=0.15 W=0.42 AS=0.0609 AD=0.2279 PS=0.71 PD=1.74
M$306 HI|VPB|VPWR \$440 A|X HI|VPB|VPWR sky130_fd_pr__pfet_01v8_hvt L=0.15 W=1
+ AS=0.2279 AD=0.26 PS=1.74 PD=2.52
M$307 HI|VPB|VPWR A|X \$442 HI|VPB|VPWR sky130_fd_pr__pfet_01v8_hvt L=0.15 W=2
+ AS=0.395 AD=0.27 PS=3.79 PD=2.54
M$309 HI|VPB|VPWR \$442 S|X HI|VPB|VPWR sky130_fd_pr__pfet_01v8_hvt L=0.15 W=6
+ AS=0.81 AD=0.935 PS=7.62 PD=8.87
M$315 HI|VPB|VPWR A_N|C|PWRITE \$444 HI|VPB|VPWR sky130_fd_pr__pfet_01v8_hvt
+ L=0.15 W=0.42 AS=0.14575 AD=0.1092 PS=1.335 PD=1.36
M$316 HI|VPB|VPWR B|PREADY|X A|Y HI|VPB|VPWR sky130_fd_pr__pfet_01v8_hvt L=0.15
+ W=1 AS=0.14575 AD=0.135 PS=1.335 PD=1.27
M$317 A|Y \$444 HI|VPB|VPWR HI|VPB|VPWR sky130_fd_pr__pfet_01v8_hvt L=0.15 W=1
+ AS=0.135 AD=0.265 PS=1.27 PD=2.53
M$318 HI|VPB|VPWR A|Y \$449 HI|VPB|VPWR sky130_fd_pr__pfet_01v8_hvt L=0.15
+ W=0.64 AS=0.149 AD=0.1664 PS=1.325 PD=1.8
M$319 HI|VPB|VPWR \$449 A|B1|X HI|VPB|VPWR sky130_fd_pr__pfet_01v8_hvt L=0.15
+ W=2 AS=0.284 AD=0.4 PS=2.595 PD=3.8
M$321 \$457 A|X HI|VPB|VPWR HI|VPB|VPWR sky130_fd_pr__pfet_01v8_hvt L=0.15 W=1
+ AS=0.26 AD=0.135 PS=2.52 PD=1.27
M$322 HI|VPB|VPWR \$457 D|X HI|VPB|VPWR sky130_fd_pr__pfet_01v8_hvt L=0.15 W=4
+ AS=0.54 AD=0.665 PS=5.08 PD=6.33
M$326 A2|Y A0|B2|Q|gpio_oe[2] \$507 HI|VPB|VPWR sky130_fd_pr__pfet_01v8_hvt
+ L=0.15 W=1 AS=0.26 AD=0.135 PS=2.52 PD=1.27
M$327 \$507 B|B1|B_N|Y A2|Y HI|VPB|VPWR sky130_fd_pr__pfet_01v8_hvt L=0.15 W=1
+ AS=0.135 AD=0.26 PS=1.27 PD=2.52
M$328 HI|VPB|VPWR A0|A1|Q|gpio_out[2] \$507 HI|VPB|VPWR
+ sky130_fd_pr__pfet_01v8_hvt L=0.15 W=1 AS=0.26 AD=0.135 PS=2.52 PD=1.27
M$329 \$507 A2|B|C2|Y HI|VPB|VPWR HI|VPB|VPWR sky130_fd_pr__pfet_01v8_hvt
+ L=0.15 W=1 AS=0.135 AD=0.3 PS=1.27 PD=2.6
M$330 HI|VPB|VPWR A1|gpio_in[2] \$518 HI|VPB|VPWR sky130_fd_pr__pfet_01v8_hvt
+ L=0.15 W=0.64 AS=0.1696 AD=0.0768 PS=1.81 PD=0.88
M$331 \$518 A|A2|C|D_N|X A1|Y HI|VPB|VPWR sky130_fd_pr__pfet_01v8_hvt L=0.15
+ W=0.64 AS=0.0768 AD=0.0896 PS=0.88 PD=0.92
M$333 \$510 A|PADDR[4] HI|VPB|VPWR HI|VPB|VPWR sky130_fd_pr__pfet_01v8_hvt
+ L=0.15 W=4 AS=0.685 AD=0.54 PS=6.37 PD=5.08
M$337 \$510 B|PADDR[5] \$512 HI|VPB|VPWR sky130_fd_pr__pfet_01v8_hvt L=0.15 W=4
+ AS=0.54 AD=0.665 PS=5.08 PD=6.33
M$341 \$458 B|B1|B_N|Y HI|VPB|VPWR HI|VPB|VPWR sky130_fd_pr__pfet_01v8_hvt
+ L=0.15 W=0.42 AS=0.1092 AD=0.1573 PS=1.36 PD=1.39
M$342 HI|VPB|VPWR A|A_N|Y \$505 HI|VPB|VPWR sky130_fd_pr__pfet_01v8_hvt L=0.15
+ W=1 AS=0.1573 AD=0.105 PS=1.39 PD=1.21
M$343 \$505 \$458 A|Y HI|VPB|VPWR sky130_fd_pr__pfet_01v8_hvt L=0.15 W=1
+ AS=0.105 AD=0.26 PS=1.21 PD=2.52
M$344 \$513 A|A2|C|D_N|X \$512 HI|VPB|VPWR sky130_fd_pr__pfet_01v8_hvt L=0.15
+ W=4 AS=0.665 AD=0.54 PS=6.33 PD=5.08
M$348 \$513 C|C_N|D|D_N|PADDR[3] A2|B|C2|Y HI|VPB|VPWR
+ sky130_fd_pr__pfet_01v8_hvt L=0.15 W=4 AS=0.54 AD=0.665 PS=5.08 PD=6.33
M$352 HI|VPB|VPWR B|B1|Y B|Y HI|VPB|VPWR sky130_fd_pr__pfet_01v8_hvt L=0.15 W=1
+ AS=0.26 AD=0.135 PS=2.52 PD=1.27
M$353 B|Y A|A2|C|D_N|X HI|VPB|VPWR HI|VPB|VPWR sky130_fd_pr__pfet_01v8_hvt
+ L=0.15 W=1 AS=0.135 AD=0.26 PS=1.27 PD=2.52
M$354 \$516 A|B1|X HI|VPB|VPWR HI|VPB|VPWR sky130_fd_pr__pfet_01v8_hvt L=0.15
+ W=2 AS=0.415 AD=0.27 PS=3.83 PD=2.54
M$356 \$516 B|Y PRDATA[8]|Y HI|VPB|VPWR sky130_fd_pr__pfet_01v8_hvt L=0.15 W=2
+ AS=0.27 AD=0.395 PS=2.54 PD=3.79
M$358 HI|VPB|VPWR A|PSEL \$447 HI|VPB|VPWR sky130_fd_pr__pfet_01v8_hvt L=0.15
+ W=0.42 AS=0.1176 AD=0.0567 PS=1.4 PD=0.69
M$359 HI|VPB|VPWR B|PENABLE \$447 HI|VPB|VPWR sky130_fd_pr__pfet_01v8_hvt
+ L=0.15 W=0.42 AS=0.16655 AD=0.0567 PS=1.39 PD=0.69
M$360 HI|VPB|VPWR \$447 A|X HI|VPB|VPWR sky130_fd_pr__pfet_01v8_hvt L=0.15 W=1
+ AS=0.16655 AD=0.475 PS=1.39 PD=2.95
M$361 HI|VPB|VPWR A_N|C|PWRITE A|A_N|Y HI|VPB|VPWR sky130_fd_pr__pfet_01v8_hvt
+ L=0.15 W=1 AS=0.26 AD=0.135 PS=2.52 PD=1.27
M$362 A|A_N|Y B|PENABLE HI|VPB|VPWR HI|VPB|VPWR sky130_fd_pr__pfet_01v8_hvt
+ L=0.15 W=1 AS=0.135 AD=0.165 PS=1.27 PD=1.33
M$363 HI|VPB|VPWR A|PSEL A|A_N|Y HI|VPB|VPWR sky130_fd_pr__pfet_01v8_hvt L=0.15
+ W=1 AS=0.165 AD=0.26 PS=1.33 PD=2.52
M$364 \$528 A|X HI|VPB|VPWR HI|VPB|VPWR sky130_fd_pr__pfet_01v8_hvt L=0.15 W=1
+ AS=0.26 AD=0.135 PS=2.52 PD=1.27
M$365 HI|VPB|VPWR \$528 D|X HI|VPB|VPWR sky130_fd_pr__pfet_01v8_hvt L=0.15 W=4
+ AS=0.54 AD=0.665 PS=5.08 PD=6.33
M$369 HI|VPB|VPWR \$535 A0|B2|Q|gpio_oe[2] HI|VPB|VPWR
+ sky130_fd_pr__pfet_01v8_hvt L=0.15 W=1 AS=0.3012 AD=0.26 PS=2.66 PD=2.52
M$370 \$599 A2|Y HI|VPB|VPWR HI|VPB|VPWR sky130_fd_pr__pfet_01v8_hvt L=0.15 W=2
+ AS=0.415 AD=0.275 PS=3.83 PD=2.55
M$371 HI|VPB|VPWR A1|Y \$599 HI|VPB|VPWR sky130_fd_pr__pfet_01v8_hvt L=0.15 W=2
+ AS=0.28 AD=0.275 PS=2.56 PD=2.55
M$374 \$599 A|B1|X PRDATA[2]|Y HI|VPB|VPWR sky130_fd_pr__pfet_01v8_hvt L=0.15
+ W=2 AS=0.27 AD=0.495 PS=2.54 PD=3.99
M$376 HI|VPB|VPWR A|PCLK \$538 HI|VPB|VPWR sky130_fd_pr__pfet_01v8_hvt L=0.15
+ W=4 AS=0.685 AD=0.56 PS=6.37 PD=5.12
M$380 HI|VPB|VPWR \$538 A|X HI|VPB|VPWR sky130_fd_pr__pfet_01v8_hvt L=0.15 W=16
+ AS=2.2375 AD=2.3625 PS=20.475 PD=21.725
M$396 HI|VPB|VPWR C|C_N|D|D_N|PADDR[3] \$582 HI|VPB|VPWR
+ sky130_fd_pr__pfet_01v8_hvt L=0.15 W=0.42 AS=0.14575 AD=0.1092 PS=1.335
+ PD=1.36
M$397 A2|B1|Y \$582 \$604 HI|VPB|VPWR sky130_fd_pr__pfet_01v8_hvt L=0.15 W=1
+ AS=0.52 AD=0.135 PS=3.04 PD=1.27
M$398 \$604 A|A2|C|D_N|X \$606 HI|VPB|VPWR sky130_fd_pr__pfet_01v8_hvt L=0.15
+ W=1 AS=0.135 AD=0.165 PS=1.27 PD=1.33
M$399 \$606 B|PADDR[5] \$605 HI|VPB|VPWR sky130_fd_pr__pfet_01v8_hvt L=0.15 W=1
+ AS=0.165 AD=0.135 PS=1.33 PD=1.27
M$400 \$605 A|PADDR[4] HI|VPB|VPWR HI|VPB|VPWR sky130_fd_pr__pfet_01v8_hvt
+ L=0.15 W=1 AS=0.135 AD=0.14575 PS=1.27 PD=1.335
M$401 \$594 A|PADDR[4] HI|VPB|VPWR HI|VPB|VPWR sky130_fd_pr__pfet_01v8_hvt
+ L=0.15 W=4 AS=0.665 AD=0.54 PS=6.33 PD=5.08
M$405 \$594 B|PADDR[5] \$595 HI|VPB|VPWR sky130_fd_pr__pfet_01v8_hvt L=0.15 W=4
+ AS=0.54 AD=0.665 PS=5.08 PD=6.33
M$409 \$600 C|C_N|D|D_N|PADDR[3] \$595 HI|VPB|VPWR sky130_fd_pr__pfet_01v8_hvt
+ L=0.15 W=4 AS=0.665 AD=0.54 PS=6.33 PD=5.08
M$413 \$600 \$539 B|B1|B_N|Y HI|VPB|VPWR sky130_fd_pr__pfet_01v8_hvt L=0.15 W=4
+ AS=0.54 AD=0.665 PS=5.08 PD=6.33
M$417 \$539 A|A2|C|D_N|X HI|VPB|VPWR HI|VPB|VPWR sky130_fd_pr__pfet_01v8_hvt
+ L=0.15 W=1 AS=0.26 AD=0.28 PS=2.52 PD=2.56
M$418 \$596 A|X HI|VPB|VPWR HI|VPB|VPWR sky130_fd_pr__pfet_01v8_hvt L=0.15 W=2
+ AS=0.415 AD=0.27 PS=3.83 PD=2.54
M$420 \$596 B|Y PRDATA[30]|Y HI|VPB|VPWR sky130_fd_pr__pfet_01v8_hvt L=0.15 W=2
+ AS=0.27 AD=0.395 PS=2.54 PD=3.79
M$422 \$597 A|X HI|VPB|VPWR HI|VPB|VPWR sky130_fd_pr__pfet_01v8_hvt L=0.15 W=2
+ AS=0.415 AD=0.27 PS=3.83 PD=2.54
M$424 \$597 B|Y PRDATA[20]|Y HI|VPB|VPWR sky130_fd_pr__pfet_01v8_hvt L=0.15 W=2
+ AS=0.27 AD=0.395 PS=2.54 PD=3.79
M$426 \$608 S|X HI|VPB|VPWR HI|VPB|VPWR sky130_fd_pr__pfet_01v8_hvt L=0.15 W=1
+ AS=0.26 AD=0.1625 PS=2.52 PD=1.325
M$427 HI|VPB|VPWR \$608 \$609 HI|VPB|VPWR sky130_fd_pr__pfet_01v8_hvt L=0.15
+ W=1 AS=0.1625 AD=0.28 PS=1.325 PD=2.56
M$428 HI|VPB|VPWR S|X \$695 HI|VPB|VPWR sky130_fd_pr__pfet_01v8_hvt L=0.15
+ W=0.42 AS=0.15835 AD=0.07665 PS=1.395 PD=0.785
M$429 \$695 A0|B2|Q|gpio_oe[2] \$639 HI|VPB|VPWR sky130_fd_pr__pfet_01v8_hvt
+ L=0.15 W=0.42 AS=0.07665 AD=0.1932 PS=0.785 PD=1.34
M$430 \$639 A1|PWDATA[2] \$696 HI|VPB|VPWR sky130_fd_pr__pfet_01v8_hvt L=0.15
+ W=0.42 AS=0.1932 AD=0.0441 PS=1.34 PD=0.63
M$431 \$696 \$640 HI|VPB|VPWR HI|VPB|VPWR sky130_fd_pr__pfet_01v8_hvt L=0.15
+ W=0.42 AS=0.0441 AD=0.0693 PS=0.63 PD=0.75
M$432 HI|VPB|VPWR S|X \$640 HI|VPB|VPWR sky130_fd_pr__pfet_01v8_hvt L=0.15
+ W=0.42 AS=0.0693 AD=0.1176 PS=0.75 PD=1.4
M$433 A|X \$639 HI|VPB|VPWR HI|VPB|VPWR sky130_fd_pr__pfet_01v8_hvt L=0.15 W=1
+ AS=0.26 AD=0.15835 PS=2.52 PD=1.395
M$434 \$610 A0|A1|Q|gpio_out[2] \$611 HI|VPB|VPWR sky130_fd_pr__pfet_01v8_hvt
+ L=0.15 W=1 AS=0.26 AD=0.16 PS=2.52 PD=1.32
M$435 \$611 A1|PWDATA[2] \$609 HI|VPB|VPWR sky130_fd_pr__pfet_01v8_hvt L=0.15
+ W=1 AS=0.16 AD=0.3 PS=1.32 PD=2.6
M$436 \$610 S|X HI|VPB|VPWR HI|VPB|VPWR sky130_fd_pr__pfet_01v8_hvt L=0.15 W=1
+ AS=0.26 AD=0.135 PS=2.52 PD=1.27
M$437 HI|VPB|VPWR \$611 A|X HI|VPB|VPWR sky130_fd_pr__pfet_01v8_hvt L=0.15 W=4
+ AS=0.54 AD=0.665 PS=5.08 PD=6.33
M$441 \$530 CLK|X HI|VPB|VPWR HI|VPB|VPWR sky130_fd_pr__pfet_01v8_hvt L=0.15
+ W=0.64 AS=0.1664 AD=0.0864 PS=1.8 PD=0.91
M$442 HI|VPB|VPWR \$530 \$531 HI|VPB|VPWR sky130_fd_pr__pfet_01v8_hvt L=0.15
+ W=0.64 AS=0.0864 AD=0.1664 PS=0.91 PD=1.8
M$443 HI|VPB|VPWR A|X \$641 HI|VPB|VPWR sky130_fd_pr__pfet_01v8_hvt L=0.15 W=2
+ AS=0.395 AD=0.27 PS=3.79 PD=2.54
M$445 HI|VPB|VPWR \$641 D|X HI|VPB|VPWR sky130_fd_pr__pfet_01v8_hvt L=0.15 W=6
+ AS=0.81 AD=0.935 PS=7.62 PD=8.87
M$451 HI|VPB|VPWR D|X \$532 HI|VPB|VPWR sky130_fd_pr__pfet_01v8_hvt L=0.15
+ W=0.42 AS=0.1092 AD=0.0651 PS=1.36 PD=0.73
M$452 \$532 \$531 \$533 HI|VPB|VPWR sky130_fd_pr__pfet_01v8_hvt L=0.15 W=0.42
+ AS=0.0651 AD=0.07245 PS=0.73 PD=0.765
M$453 \$533 \$530 \$598 HI|VPB|VPWR sky130_fd_pr__pfet_01v8_hvt L=0.15 W=0.42
+ AS=0.07245 AD=0.1155 PS=0.765 PD=0.97
M$454 \$598 \$593 HI|VPB|VPWR HI|VPB|VPWR sky130_fd_pr__pfet_01v8_hvt L=0.15
+ W=0.42 AS=0.1155 AD=0.07035 PS=0.97 PD=0.755
M$455 HI|VPB|VPWR PRESETn|RESET_B \$598 HI|VPB|VPWR sky130_fd_pr__pfet_01v8_hvt
+ L=0.15 W=0.42 AS=0.07035 AD=0.1092 PS=0.755 PD=1.36
M$456 \$613 CLK|X HI|VPB|VPWR HI|VPB|VPWR sky130_fd_pr__pfet_01v8_hvt L=0.15
+ W=0.64 AS=0.1664 AD=0.0864 PS=1.8 PD=0.91
M$457 HI|VPB|VPWR \$613 \$614 HI|VPB|VPWR sky130_fd_pr__pfet_01v8_hvt L=0.15
+ W=0.64 AS=0.0864 AD=0.1664 PS=0.91 PD=1.8
M$458 HI|VPB|VPWR D|X \$616 HI|VPB|VPWR sky130_fd_pr__pfet_01v8_hvt L=0.15
+ W=0.42 AS=0.1092 AD=0.0651 PS=1.36 PD=0.73
M$459 \$616 \$614 \$617 HI|VPB|VPWR sky130_fd_pr__pfet_01v8_hvt L=0.15 W=0.42
+ AS=0.0651 AD=0.07245 PS=0.73 PD=0.765
M$460 \$617 \$613 \$618 HI|VPB|VPWR sky130_fd_pr__pfet_01v8_hvt L=0.15 W=0.42
+ AS=0.07245 AD=0.1155 PS=0.765 PD=0.97
M$461 \$618 \$619 HI|VPB|VPWR HI|VPB|VPWR sky130_fd_pr__pfet_01v8_hvt L=0.15
+ W=0.42 AS=0.1155 AD=0.07035 PS=0.97 PD=0.755
M$462 HI|VPB|VPWR PRESETn|RESET_B \$618 HI|VPB|VPWR sky130_fd_pr__pfet_01v8_hvt
+ L=0.15 W=0.42 AS=0.07035 AD=0.1092 PS=0.755 PD=1.36
M$463 HI|VPB|VPWR \$533 \$593 HI|VPB|VPWR sky130_fd_pr__pfet_01v8_hvt L=0.15
+ W=0.84 AS=0.2184 AD=0.12915 PS=2.2 PD=1.185
M$464 \$593 \$530 \$534 HI|VPB|VPWR sky130_fd_pr__pfet_01v8_hvt L=0.15 W=0.42
+ AS=0.12915 AD=0.0588 PS=1.185 PD=0.7
M$465 \$534 \$531 \$601 HI|VPB|VPWR sky130_fd_pr__pfet_01v8_hvt L=0.15 W=0.42
+ AS=0.0588 AD=0.0567 PS=0.7 PD=0.69
M$466 \$601 \$535 HI|VPB|VPWR HI|VPB|VPWR sky130_fd_pr__pfet_01v8_hvt L=0.15
+ W=0.42 AS=0.0567 AD=0.0819 PS=0.69 PD=0.81
M$467 HI|VPB|VPWR PRESETn|RESET_B \$535 HI|VPB|VPWR sky130_fd_pr__pfet_01v8_hvt
+ L=0.15 W=0.42 AS=0.0819 AD=0.0567 PS=0.81 PD=0.69
M$468 \$535 \$534 HI|VPB|VPWR HI|VPB|VPWR sky130_fd_pr__pfet_01v8_hvt L=0.15
+ W=0.42 AS=0.0567 AD=0.1134 PS=0.69 PD=1.38
M$469 \$619 \$613 \$620 HI|VPB|VPWR sky130_fd_pr__pfet_01v8_hvt L=0.15 W=0.42
+ AS=0.12915 AD=0.0588 PS=1.185 PD=0.7
M$470 \$620 \$614 \$630 HI|VPB|VPWR sky130_fd_pr__pfet_01v8_hvt L=0.15 W=0.42
+ AS=0.0588 AD=0.0567 PS=0.7 PD=0.69
M$471 \$630 \$621 HI|VPB|VPWR HI|VPB|VPWR sky130_fd_pr__pfet_01v8_hvt L=0.15
+ W=0.42 AS=0.0567 AD=0.0819 PS=0.69 PD=0.81
M$472 HI|VPB|VPWR PRESETn|RESET_B \$621 HI|VPB|VPWR sky130_fd_pr__pfet_01v8_hvt
+ L=0.15 W=0.42 AS=0.0819 AD=0.0567 PS=0.81 PD=0.69
M$473 \$621 \$620 HI|VPB|VPWR HI|VPB|VPWR sky130_fd_pr__pfet_01v8_hvt L=0.15
+ W=0.42 AS=0.0567 AD=0.1134 PS=0.69 PD=1.38
M$474 HI|VPB|VPWR \$617 \$619 HI|VPB|VPWR sky130_fd_pr__pfet_01v8_hvt L=0.15
+ W=0.84 AS=0.2184 AD=0.12915 PS=2.2 PD=1.185
M$475 HI|VPB|VPWR \$621 A0|A1|Q|gpio_out[2] HI|VPB|VPWR
+ sky130_fd_pr__pfet_01v8_hvt L=0.15 W=1 AS=0.3012 AD=0.26 PS=2.66 PD=2.52
M$476 HI|VPB|VPWR A|X \$643 HI|VPB|VPWR sky130_fd_pr__pfet_01v8_hvt L=0.15 W=2
+ AS=0.395 AD=0.27 PS=3.79 PD=2.54
M$478 HI|VPB|VPWR \$643 D|X HI|VPB|VPWR sky130_fd_pr__pfet_01v8_hvt L=0.15 W=6
+ AS=0.81 AD=0.935 PS=7.62 PD=8.87
M$484 HI|VPB|VPWR A|B1|X \$622 HI|VPB|VPWR sky130_fd_pr__pfet_01v8_hvt L=0.15
+ W=0.64 AS=0.149 AD=0.1664 PS=1.325 PD=1.8
M$485 HI|VPB|VPWR \$622 A|X HI|VPB|VPWR sky130_fd_pr__pfet_01v8_hvt L=0.15 W=2
+ AS=0.284 AD=0.4 PS=2.595 PD=3.8
M$487 \$623 A|PADDR[4] HI|VPB|VPWR HI|VPB|VPWR sky130_fd_pr__pfet_01v8_hvt
+ L=0.15 W=2 AS=0.415 AD=0.27 PS=3.83 PD=2.54
M$489 \$623 B|PADDR[5] \$624 HI|VPB|VPWR sky130_fd_pr__pfet_01v8_hvt L=0.15 W=2
+ AS=0.27 AD=0.415 PS=2.54 PD=3.83
M$491 \$624 \$625 B|B1|Y HI|VPB|VPWR sky130_fd_pr__pfet_01v8_hvt L=0.15 W=2
+ AS=0.415 AD=0.415 PS=3.83 PD=3.83
M$493 \$625 C|C_N|D|D_N|PADDR[3] HI|VPB|VPWR HI|VPB|VPWR
+ sky130_fd_pr__pfet_01v8_hvt L=0.15 W=0.42 AS=0.1092 AD=0.1092 PS=1.36 PD=1.36
M$494 \$692 A|X HI|VPB|VPWR HI|VPB|VPWR sky130_fd_pr__pfet_01v8_hvt L=0.15 W=2
+ AS=0.415 AD=0.27 PS=3.83 PD=2.54
M$496 \$692 B|Y PRDATA[24]|Y HI|VPB|VPWR sky130_fd_pr__pfet_01v8_hvt L=0.15 W=2
+ AS=0.27 AD=0.395 PS=2.54 PD=3.79
M$498 \$626 A|X HI|VPB|VPWR HI|VPB|VPWR sky130_fd_pr__pfet_01v8_hvt L=0.15 W=2
+ AS=0.415 AD=0.27 PS=3.83 PD=2.54
M$500 \$626 B|Y PRDATA[26]|Y HI|VPB|VPWR sky130_fd_pr__pfet_01v8_hvt L=0.15 W=2
+ AS=0.27 AD=0.395 PS=2.54 PD=3.79
M$502 \$628 A|X HI|VPB|VPWR HI|VPB|VPWR sky130_fd_pr__pfet_01v8_hvt L=0.15 W=2
+ AS=0.415 AD=0.27 PS=3.83 PD=2.54
M$504 \$628 B|Y PRDATA[22]|Y HI|VPB|VPWR sky130_fd_pr__pfet_01v8_hvt L=0.15 W=2
+ AS=0.27 AD=0.395 PS=2.54 PD=3.79
M$506 \$693 A|X HI|VPB|VPWR HI|VPB|VPWR sky130_fd_pr__pfet_01v8_hvt L=0.15 W=2
+ AS=0.415 AD=0.27 PS=3.83 PD=2.54
M$508 \$693 B|Y PRDATA[25]|Y HI|VPB|VPWR sky130_fd_pr__pfet_01v8_hvt L=0.15 W=2
+ AS=0.27 AD=0.395 PS=2.54 PD=3.79
M$510 \$694 A|X HI|VPB|VPWR HI|VPB|VPWR sky130_fd_pr__pfet_01v8_hvt L=0.15 W=2
+ AS=0.415 AD=0.27 PS=3.83 PD=2.54
M$512 \$694 B|Y PRDATA[14]|Y HI|VPB|VPWR sky130_fd_pr__pfet_01v8_hvt L=0.15 W=2
+ AS=0.27 AD=0.395 PS=2.54 PD=3.79
M$514 HI|VPB|VPWR A|X \$699 HI|VPB|VPWR sky130_fd_pr__pfet_01v8_hvt L=0.15 W=4
+ AS=0.685 AD=0.56 PS=6.37 PD=5.12
M$518 HI|VPB|VPWR \$699 CLK|X HI|VPB|VPWR sky130_fd_pr__pfet_01v8_hvt L=0.15
+ W=16 AS=2.2375 AD=2.3625 PS=20.475 PD=21.725
M$534 \$701 A|X HI|VPB|VPWR HI|VPB|VPWR sky130_fd_pr__pfet_01v8_hvt L=0.15 W=1
+ AS=0.26 AD=0.135 PS=2.52 PD=1.27
M$535 HI|VPB|VPWR \$701 D|X HI|VPB|VPWR sky130_fd_pr__pfet_01v8_hvt L=0.15 W=4
+ AS=0.54 AD=0.665 PS=5.08 PD=6.33
M$539 HI|VPB|VPWR B|B1|B_N|Y A1|Y HI|VPB|VPWR sky130_fd_pr__pfet_01v8_hvt
+ L=0.15 W=1 AS=0.26 AD=0.135 PS=2.52 PD=1.27
M$540 A1|Y A|A0|Q|gpio_oe[4] HI|VPB|VPWR HI|VPB|VPWR
+ sky130_fd_pr__pfet_01v8_hvt L=0.15 W=1 AS=0.135 AD=0.26 PS=1.27 PD=2.52
M$541 \$706 A2|Y HI|VPB|VPWR HI|VPB|VPWR sky130_fd_pr__pfet_01v8_hvt L=0.15 W=2
+ AS=0.415 AD=0.275 PS=3.83 PD=2.55
M$542 HI|VPB|VPWR A1|Y \$706 HI|VPB|VPWR sky130_fd_pr__pfet_01v8_hvt L=0.15 W=2
+ AS=0.28 AD=0.275 PS=2.56 PD=2.55
M$545 \$706 A|B1|X PRDATA[4]|Y HI|VPB|VPWR sky130_fd_pr__pfet_01v8_hvt L=0.15
+ W=2 AS=0.27 AD=0.495 PS=2.54 PD=3.99
M$547 \$708 A|X HI|VPB|VPWR HI|VPB|VPWR sky130_fd_pr__pfet_01v8_hvt L=0.15 W=2
+ AS=0.415 AD=0.27 PS=3.83 PD=2.54
M$549 \$708 B|Y PRDATA[11]|Y HI|VPB|VPWR sky130_fd_pr__pfet_01v8_hvt L=0.15 W=2
+ AS=0.27 AD=0.395 PS=2.54 PD=3.79
M$551 HI|VPB|VPWR A|X \$716 HI|VPB|VPWR sky130_fd_pr__pfet_01v8_hvt L=0.15 W=2
+ AS=0.395 AD=0.27 PS=3.79 PD=2.54
M$553 HI|VPB|VPWR \$716 D|X HI|VPB|VPWR sky130_fd_pr__pfet_01v8_hvt L=0.15 W=6
+ AS=0.81 AD=0.935 PS=7.62 PD=8.87
M$559 \$718 A|X HI|VPB|VPWR HI|VPB|VPWR sky130_fd_pr__pfet_01v8_hvt L=0.15 W=1
+ AS=0.26 AD=0.135 PS=2.52 PD=1.27
M$560 HI|VPB|VPWR \$718 D|X HI|VPB|VPWR sky130_fd_pr__pfet_01v8_hvt L=0.15 W=4
+ AS=0.54 AD=0.665 PS=5.08 PD=6.33
M$564 \$720 CLK|X HI|VPB|VPWR HI|VPB|VPWR sky130_fd_pr__pfet_01v8_hvt L=0.15
+ W=0.64 AS=0.1664 AD=0.0864 PS=1.8 PD=0.91
M$565 HI|VPB|VPWR \$720 \$721 HI|VPB|VPWR sky130_fd_pr__pfet_01v8_hvt L=0.15
+ W=0.64 AS=0.0864 AD=0.1664 PS=0.91 PD=1.8
M$566 HI|VPB|VPWR D|X \$722 HI|VPB|VPWR sky130_fd_pr__pfet_01v8_hvt L=0.15
+ W=0.42 AS=0.1092 AD=0.0651 PS=1.36 PD=0.73
M$567 \$722 \$721 \$723 HI|VPB|VPWR sky130_fd_pr__pfet_01v8_hvt L=0.15 W=0.42
+ AS=0.0651 AD=0.07245 PS=0.73 PD=0.765
M$568 \$723 \$720 \$781 HI|VPB|VPWR sky130_fd_pr__pfet_01v8_hvt L=0.15 W=0.42
+ AS=0.07245 AD=0.1155 PS=0.765 PD=0.97
M$569 \$781 \$779 HI|VPB|VPWR HI|VPB|VPWR sky130_fd_pr__pfet_01v8_hvt L=0.15
+ W=0.42 AS=0.1155 AD=0.07035 PS=0.97 PD=0.755
M$570 HI|VPB|VPWR PRESETn|RESET_B \$781 HI|VPB|VPWR sky130_fd_pr__pfet_01v8_hvt
+ L=0.15 W=0.42 AS=0.07035 AD=0.1092 PS=0.755 PD=1.36
M$571 HI|VPB|VPWR \$723 \$779 HI|VPB|VPWR sky130_fd_pr__pfet_01v8_hvt L=0.15
+ W=0.84 AS=0.2184 AD=0.12915 PS=2.2 PD=1.185
M$572 \$779 \$720 \$724 HI|VPB|VPWR sky130_fd_pr__pfet_01v8_hvt L=0.15 W=0.42
+ AS=0.12915 AD=0.0588 PS=1.185 PD=0.7
M$573 \$724 \$721 \$785 HI|VPB|VPWR sky130_fd_pr__pfet_01v8_hvt L=0.15 W=0.42
+ AS=0.0588 AD=0.0567 PS=0.7 PD=0.69
M$574 \$785 \$725 HI|VPB|VPWR HI|VPB|VPWR sky130_fd_pr__pfet_01v8_hvt L=0.15
+ W=0.42 AS=0.0567 AD=0.0819 PS=0.69 PD=0.81
M$575 HI|VPB|VPWR PRESETn|RESET_B \$725 HI|VPB|VPWR sky130_fd_pr__pfet_01v8_hvt
+ L=0.15 W=0.42 AS=0.0819 AD=0.0567 PS=0.81 PD=0.69
M$576 \$725 \$724 HI|VPB|VPWR HI|VPB|VPWR sky130_fd_pr__pfet_01v8_hvt L=0.15
+ W=0.42 AS=0.0567 AD=0.1134 PS=0.69 PD=1.38
M$577 HI|VPB|VPWR \$725 A0|C1|Q|gpio_out[5] HI|VPB|VPWR
+ sky130_fd_pr__pfet_01v8_hvt L=0.15 W=1 AS=0.3012 AD=0.26 PS=2.66 PD=2.52
M$578 \$726 CLK|X HI|VPB|VPWR HI|VPB|VPWR sky130_fd_pr__pfet_01v8_hvt L=0.15
+ W=0.64 AS=0.1664 AD=0.0864 PS=1.8 PD=0.91
M$579 HI|VPB|VPWR \$726 \$727 HI|VPB|VPWR sky130_fd_pr__pfet_01v8_hvt L=0.15
+ W=0.64 AS=0.0864 AD=0.1664 PS=0.91 PD=1.8
M$580 HI|VPB|VPWR D|X \$728 HI|VPB|VPWR sky130_fd_pr__pfet_01v8_hvt L=0.15
+ W=0.42 AS=0.1092 AD=0.0651 PS=1.36 PD=0.73
M$581 \$728 \$727 \$729 HI|VPB|VPWR sky130_fd_pr__pfet_01v8_hvt L=0.15 W=0.42
+ AS=0.0651 AD=0.07245 PS=0.73 PD=0.765
M$582 \$729 \$726 \$782 HI|VPB|VPWR sky130_fd_pr__pfet_01v8_hvt L=0.15 W=0.42
+ AS=0.07245 AD=0.1155 PS=0.765 PD=0.97
M$583 \$782 \$780 HI|VPB|VPWR HI|VPB|VPWR sky130_fd_pr__pfet_01v8_hvt L=0.15
+ W=0.42 AS=0.1155 AD=0.07035 PS=0.97 PD=0.755
M$584 HI|VPB|VPWR PRESETn|RESET_B \$782 HI|VPB|VPWR sky130_fd_pr__pfet_01v8_hvt
+ L=0.15 W=0.42 AS=0.07035 AD=0.1092 PS=0.755 PD=1.36
M$585 HI|VPB|VPWR \$729 \$780 HI|VPB|VPWR sky130_fd_pr__pfet_01v8_hvt L=0.15
+ W=0.84 AS=0.2184 AD=0.12915 PS=2.2 PD=1.185
M$586 \$780 \$726 \$730 HI|VPB|VPWR sky130_fd_pr__pfet_01v8_hvt L=0.15 W=0.42
+ AS=0.12915 AD=0.0588 PS=1.185 PD=0.7
M$587 \$730 \$727 \$784 HI|VPB|VPWR sky130_fd_pr__pfet_01v8_hvt L=0.15 W=0.42
+ AS=0.0588 AD=0.0567 PS=0.7 PD=0.69
M$588 \$784 \$731 HI|VPB|VPWR HI|VPB|VPWR sky130_fd_pr__pfet_01v8_hvt L=0.15
+ W=0.42 AS=0.0567 AD=0.0819 PS=0.69 PD=0.81
M$589 HI|VPB|VPWR PRESETn|RESET_B \$731 HI|VPB|VPWR sky130_fd_pr__pfet_01v8_hvt
+ L=0.15 W=0.42 AS=0.0819 AD=0.0567 PS=0.81 PD=0.69
M$590 \$731 \$730 HI|VPB|VPWR HI|VPB|VPWR sky130_fd_pr__pfet_01v8_hvt L=0.15
+ W=0.42 AS=0.0567 AD=0.1134 PS=0.69 PD=1.38
M$591 HI|VPB|VPWR \$731 A|A0|Q|gpio_oe[4] HI|VPB|VPWR
+ sky130_fd_pr__pfet_01v8_hvt L=0.15 W=1 AS=0.3012 AD=0.26 PS=2.66 PD=2.52
M$592 \$787 CLK|X HI|VPB|VPWR HI|VPB|VPWR sky130_fd_pr__pfet_01v8_hvt L=0.15
+ W=0.64 AS=0.1664 AD=0.0864 PS=1.8 PD=0.91
M$593 HI|VPB|VPWR \$787 \$788 HI|VPB|VPWR sky130_fd_pr__pfet_01v8_hvt L=0.15
+ W=0.64 AS=0.0864 AD=0.1664 PS=0.91 PD=1.8
M$594 HI|VPB|VPWR D|X \$790 HI|VPB|VPWR sky130_fd_pr__pfet_01v8_hvt L=0.15
+ W=0.42 AS=0.1092 AD=0.0651 PS=1.36 PD=0.73
M$595 \$790 \$788 \$791 HI|VPB|VPWR sky130_fd_pr__pfet_01v8_hvt L=0.15 W=0.42
+ AS=0.0651 AD=0.07245 PS=0.73 PD=0.765
M$596 \$791 \$787 \$792 HI|VPB|VPWR sky130_fd_pr__pfet_01v8_hvt L=0.15 W=0.42
+ AS=0.07245 AD=0.1155 PS=0.765 PD=0.97
M$597 \$792 \$793 HI|VPB|VPWR HI|VPB|VPWR sky130_fd_pr__pfet_01v8_hvt L=0.15
+ W=0.42 AS=0.1155 AD=0.07035 PS=0.97 PD=0.755
M$598 HI|VPB|VPWR PRESETn|RESET_B \$792 HI|VPB|VPWR sky130_fd_pr__pfet_01v8_hvt
+ L=0.15 W=0.42 AS=0.07035 AD=0.1092 PS=0.755 PD=1.36
M$599 \$793 \$787 \$794 HI|VPB|VPWR sky130_fd_pr__pfet_01v8_hvt L=0.15 W=0.42
+ AS=0.12915 AD=0.0588 PS=1.185 PD=0.7
M$600 \$794 \$788 \$813 HI|VPB|VPWR sky130_fd_pr__pfet_01v8_hvt L=0.15 W=0.42
+ AS=0.0588 AD=0.0567 PS=0.7 PD=0.69
M$601 \$813 \$817 HI|VPB|VPWR HI|VPB|VPWR sky130_fd_pr__pfet_01v8_hvt L=0.15
+ W=0.42 AS=0.0567 AD=0.0819 PS=0.69 PD=0.81
M$602 HI|VPB|VPWR PRESETn|RESET_B \$817 HI|VPB|VPWR sky130_fd_pr__pfet_01v8_hvt
+ L=0.15 W=0.42 AS=0.0819 AD=0.0567 PS=0.81 PD=0.69
M$603 \$817 \$794 HI|VPB|VPWR HI|VPB|VPWR sky130_fd_pr__pfet_01v8_hvt L=0.15
+ W=0.42 AS=0.0567 AD=0.1134 PS=0.69 PD=1.38
M$604 HI|VPB|VPWR \$791 \$793 HI|VPB|VPWR sky130_fd_pr__pfet_01v8_hvt L=0.15
+ W=0.84 AS=0.2184 AD=0.12915 PS=2.2 PD=1.185
M$605 HI|VPB|VPWR \$817 A0|B2|Q|gpio_oe[7] HI|VPB|VPWR
+ sky130_fd_pr__pfet_01v8_hvt L=0.15 W=1 AS=0.3012 AD=0.26 PS=2.66 PD=2.52
M$606 \$796 CLK|X HI|VPB|VPWR HI|VPB|VPWR sky130_fd_pr__pfet_01v8_hvt L=0.15
+ W=0.64 AS=0.1664 AD=0.0864 PS=1.8 PD=0.91
M$607 HI|VPB|VPWR \$796 \$797 HI|VPB|VPWR sky130_fd_pr__pfet_01v8_hvt L=0.15
+ W=0.64 AS=0.0864 AD=0.1664 PS=0.91 PD=1.8
M$608 HI|VPB|VPWR D|X \$798 HI|VPB|VPWR sky130_fd_pr__pfet_01v8_hvt L=0.15
+ W=0.42 AS=0.1092 AD=0.0651 PS=1.36 PD=0.73
M$609 \$798 \$797 \$799 HI|VPB|VPWR sky130_fd_pr__pfet_01v8_hvt L=0.15 W=0.42
+ AS=0.0651 AD=0.07245 PS=0.73 PD=0.765
M$610 \$799 \$796 \$800 HI|VPB|VPWR sky130_fd_pr__pfet_01v8_hvt L=0.15 W=0.42
+ AS=0.07245 AD=0.1155 PS=0.765 PD=0.97
M$611 \$800 \$801 HI|VPB|VPWR HI|VPB|VPWR sky130_fd_pr__pfet_01v8_hvt L=0.15
+ W=0.42 AS=0.1155 AD=0.07035 PS=0.97 PD=0.755
M$612 HI|VPB|VPWR PRESETn|RESET_B \$800 HI|VPB|VPWR sky130_fd_pr__pfet_01v8_hvt
+ L=0.15 W=0.42 AS=0.07035 AD=0.1092 PS=0.755 PD=1.36
M$613 \$801 \$796 \$802 HI|VPB|VPWR sky130_fd_pr__pfet_01v8_hvt L=0.15 W=0.42
+ AS=0.12915 AD=0.0588 PS=1.185 PD=0.7
M$614 \$802 \$797 \$814 HI|VPB|VPWR sky130_fd_pr__pfet_01v8_hvt L=0.15 W=0.42
+ AS=0.0588 AD=0.0567 PS=0.7 PD=0.69
M$615 \$814 \$818 HI|VPB|VPWR HI|VPB|VPWR sky130_fd_pr__pfet_01v8_hvt L=0.15
+ W=0.42 AS=0.0567 AD=0.0819 PS=0.69 PD=0.81
M$616 HI|VPB|VPWR PRESETn|RESET_B \$818 HI|VPB|VPWR sky130_fd_pr__pfet_01v8_hvt
+ L=0.15 W=0.42 AS=0.0819 AD=0.0567 PS=0.81 PD=0.69
M$617 \$818 \$802 HI|VPB|VPWR HI|VPB|VPWR sky130_fd_pr__pfet_01v8_hvt L=0.15
+ W=0.42 AS=0.0567 AD=0.1134 PS=0.69 PD=1.38
M$618 HI|VPB|VPWR \$799 \$801 HI|VPB|VPWR sky130_fd_pr__pfet_01v8_hvt L=0.15
+ W=0.84 AS=0.2184 AD=0.12915 PS=2.2 PD=1.185
M$619 HI|VPB|VPWR \$818 A0|B2|Q|gpio_oe[5] HI|VPB|VPWR
+ sky130_fd_pr__pfet_01v8_hvt L=0.15 W=1 AS=0.3012 AD=0.26 PS=2.66 PD=2.52
M$620 HI|VPB|VPWR S|X \$815 HI|VPB|VPWR sky130_fd_pr__pfet_01v8_hvt L=0.15
+ W=0.42 AS=0.15835 AD=0.07665 PS=1.395 PD=0.785
M$621 \$815 A|A0|Q|gpio_oe[4] \$804 HI|VPB|VPWR sky130_fd_pr__pfet_01v8_hvt
+ L=0.15 W=0.42 AS=0.07665 AD=0.1932 PS=0.785 PD=1.34
M$622 \$804 A1|PWDATA[4] \$816 HI|VPB|VPWR sky130_fd_pr__pfet_01v8_hvt L=0.15
+ W=0.42 AS=0.1932 AD=0.0441 PS=1.34 PD=0.63
M$623 \$816 \$806 HI|VPB|VPWR HI|VPB|VPWR sky130_fd_pr__pfet_01v8_hvt L=0.15
+ W=0.42 AS=0.0441 AD=0.0693 PS=0.63 PD=0.75
M$624 HI|VPB|VPWR S|X \$806 HI|VPB|VPWR sky130_fd_pr__pfet_01v8_hvt L=0.15
+ W=0.42 AS=0.0693 AD=0.1176 PS=0.75 PD=1.4
M$625 A|X \$804 HI|VPB|VPWR HI|VPB|VPWR sky130_fd_pr__pfet_01v8_hvt L=0.15 W=1
+ AS=0.26 AD=0.15835 PS=2.52 PD=1.395
M$626 \$808 S|X HI|VPB|VPWR HI|VPB|VPWR sky130_fd_pr__pfet_01v8_hvt L=0.15 W=1
+ AS=0.26 AD=0.1625 PS=2.52 PD=1.325
M$627 HI|VPB|VPWR \$808 \$809 HI|VPB|VPWR sky130_fd_pr__pfet_01v8_hvt L=0.15
+ W=1 AS=0.1625 AD=0.28 PS=1.325 PD=2.56
M$628 \$810 A0|A1|Q|gpio_out[4] \$811 HI|VPB|VPWR sky130_fd_pr__pfet_01v8_hvt
+ L=0.15 W=1 AS=0.26 AD=0.16 PS=2.52 PD=1.32
M$629 \$811 A1|PWDATA[4] \$809 HI|VPB|VPWR sky130_fd_pr__pfet_01v8_hvt L=0.15
+ W=1 AS=0.16 AD=0.3 PS=1.32 PD=2.6
M$630 \$810 S|X HI|VPB|VPWR HI|VPB|VPWR sky130_fd_pr__pfet_01v8_hvt L=0.15 W=1
+ AS=0.26 AD=0.135 PS=2.52 PD=1.27
M$631 HI|VPB|VPWR \$811 A|X HI|VPB|VPWR sky130_fd_pr__pfet_01v8_hvt L=0.15 W=4
+ AS=0.54 AD=0.665 PS=5.08 PD=6.33
M$635 \$834 A|X HI|VPB|VPWR HI|VPB|VPWR sky130_fd_pr__pfet_01v8_hvt L=0.15 W=1
+ AS=0.26 AD=0.135 PS=2.52 PD=1.27
M$636 HI|VPB|VPWR \$834 D|X HI|VPB|VPWR sky130_fd_pr__pfet_01v8_hvt L=0.15 W=4
+ AS=0.54 AD=0.665 PS=5.08 PD=6.33
M$640 \$836 S|X HI|VPB|VPWR HI|VPB|VPWR sky130_fd_pr__pfet_01v8_hvt L=0.15 W=1
+ AS=0.26 AD=0.1625 PS=2.52 PD=1.325
M$641 HI|VPB|VPWR \$836 \$898 HI|VPB|VPWR sky130_fd_pr__pfet_01v8_hvt L=0.15
+ W=1 AS=0.1625 AD=0.28 PS=1.325 PD=2.56
M$642 \$899 A0|C1|Q|gpio_out[7] \$838 HI|VPB|VPWR sky130_fd_pr__pfet_01v8_hvt
+ L=0.15 W=1 AS=0.26 AD=0.16 PS=2.52 PD=1.32
M$643 \$838 A1|PWDATA[7] \$898 HI|VPB|VPWR sky130_fd_pr__pfet_01v8_hvt L=0.15
+ W=1 AS=0.16 AD=0.3 PS=1.32 PD=2.6
M$644 \$899 S|X HI|VPB|VPWR HI|VPB|VPWR sky130_fd_pr__pfet_01v8_hvt L=0.15 W=1
+ AS=0.26 AD=0.135 PS=2.52 PD=1.27
M$645 HI|VPB|VPWR \$838 A|X HI|VPB|VPWR sky130_fd_pr__pfet_01v8_hvt L=0.15 W=4
+ AS=0.54 AD=0.665 PS=5.08 PD=6.33
M$649 HI|VPB|VPWR S|X \$905 HI|VPB|VPWR sky130_fd_pr__pfet_01v8_hvt L=0.15
+ W=0.42 AS=0.15835 AD=0.07665 PS=1.395 PD=0.785
M$650 \$905 A0|B2|Q|gpio_oe[7] \$840 HI|VPB|VPWR sky130_fd_pr__pfet_01v8_hvt
+ L=0.15 W=0.42 AS=0.07665 AD=0.1932 PS=0.785 PD=1.34
M$651 \$840 A1|PWDATA[7] \$906 HI|VPB|VPWR sky130_fd_pr__pfet_01v8_hvt L=0.15
+ W=0.42 AS=0.1932 AD=0.0441 PS=1.34 PD=0.63
M$652 \$906 \$841 HI|VPB|VPWR HI|VPB|VPWR sky130_fd_pr__pfet_01v8_hvt L=0.15
+ W=0.42 AS=0.0441 AD=0.0693 PS=0.63 PD=0.75
M$653 HI|VPB|VPWR S|X \$841 HI|VPB|VPWR sky130_fd_pr__pfet_01v8_hvt L=0.15
+ W=0.42 AS=0.0693 AD=0.1176 PS=0.75 PD=1.4
M$654 A|X \$840 HI|VPB|VPWR HI|VPB|VPWR sky130_fd_pr__pfet_01v8_hvt L=0.15 W=1
+ AS=0.26 AD=0.15835 PS=2.52 PD=1.395
M$655 \$842 S|X HI|VPB|VPWR HI|VPB|VPWR sky130_fd_pr__pfet_01v8_hvt L=0.15 W=1
+ AS=0.26 AD=0.1625 PS=2.52 PD=1.325
M$656 HI|VPB|VPWR \$842 \$900 HI|VPB|VPWR sky130_fd_pr__pfet_01v8_hvt L=0.15
+ W=1 AS=0.1625 AD=0.28 PS=1.325 PD=2.56
M$657 \$901 A0|C1|Q|gpio_out[5] \$844 HI|VPB|VPWR sky130_fd_pr__pfet_01v8_hvt
+ L=0.15 W=1 AS=0.26 AD=0.16 PS=2.52 PD=1.32
M$658 \$844 A1|PWDATA[5] \$900 HI|VPB|VPWR sky130_fd_pr__pfet_01v8_hvt L=0.15
+ W=1 AS=0.16 AD=0.3 PS=1.32 PD=2.6
M$659 \$901 S|X HI|VPB|VPWR HI|VPB|VPWR sky130_fd_pr__pfet_01v8_hvt L=0.15 W=1
+ AS=0.26 AD=0.135 PS=2.52 PD=1.27
M$660 HI|VPB|VPWR \$844 A|X HI|VPB|VPWR sky130_fd_pr__pfet_01v8_hvt L=0.15 W=4
+ AS=0.54 AD=0.665 PS=5.08 PD=6.33
M$664 \$846 CLK|X HI|VPB|VPWR HI|VPB|VPWR sky130_fd_pr__pfet_01v8_hvt L=0.15
+ W=0.64 AS=0.1664 AD=0.0864 PS=1.8 PD=0.91
M$665 HI|VPB|VPWR \$846 \$847 HI|VPB|VPWR sky130_fd_pr__pfet_01v8_hvt L=0.15
+ W=0.64 AS=0.0864 AD=0.1664 PS=0.91 PD=1.8
M$666 HI|VPB|VPWR D|X \$848 HI|VPB|VPWR sky130_fd_pr__pfet_01v8_hvt L=0.15
+ W=0.42 AS=0.1092 AD=0.0651 PS=1.36 PD=0.73
M$667 \$848 \$847 \$849 HI|VPB|VPWR sky130_fd_pr__pfet_01v8_hvt L=0.15 W=0.42
+ AS=0.0651 AD=0.07245 PS=0.73 PD=0.765
M$668 \$849 \$846 \$902 HI|VPB|VPWR sky130_fd_pr__pfet_01v8_hvt L=0.15 W=0.42
+ AS=0.07245 AD=0.1155 PS=0.765 PD=0.97
M$669 \$902 \$897 HI|VPB|VPWR HI|VPB|VPWR sky130_fd_pr__pfet_01v8_hvt L=0.15
+ W=0.42 AS=0.1155 AD=0.07035 PS=0.97 PD=0.755
M$670 HI|VPB|VPWR PRESETn|RESET_B \$902 HI|VPB|VPWR sky130_fd_pr__pfet_01v8_hvt
+ L=0.15 W=0.42 AS=0.07035 AD=0.1092 PS=0.755 PD=1.36
M$671 HI|VPB|VPWR \$849 \$897 HI|VPB|VPWR sky130_fd_pr__pfet_01v8_hvt L=0.15
+ W=0.84 AS=0.2184 AD=0.12915 PS=2.2 PD=1.185
M$672 \$897 \$846 \$850 HI|VPB|VPWR sky130_fd_pr__pfet_01v8_hvt L=0.15 W=0.42
+ AS=0.12915 AD=0.0588 PS=1.185 PD=0.7
M$673 \$850 \$847 \$907 HI|VPB|VPWR sky130_fd_pr__pfet_01v8_hvt L=0.15 W=0.42
+ AS=0.0588 AD=0.0567 PS=0.7 PD=0.69
M$674 \$907 \$851 HI|VPB|VPWR HI|VPB|VPWR sky130_fd_pr__pfet_01v8_hvt L=0.15
+ W=0.42 AS=0.0567 AD=0.0819 PS=0.69 PD=0.81
M$675 HI|VPB|VPWR PRESETn|RESET_B \$851 HI|VPB|VPWR sky130_fd_pr__pfet_01v8_hvt
+ L=0.15 W=0.42 AS=0.0819 AD=0.0567 PS=0.81 PD=0.69
M$676 \$851 \$850 HI|VPB|VPWR HI|VPB|VPWR sky130_fd_pr__pfet_01v8_hvt L=0.15
+ W=0.42 AS=0.0567 AD=0.1134 PS=0.69 PD=1.38
M$677 HI|VPB|VPWR \$851 A0|A1|Q|gpio_out[4] HI|VPB|VPWR
+ sky130_fd_pr__pfet_01v8_hvt L=0.15 W=1 AS=0.3012 AD=0.26 PS=2.66 PD=2.52
M$678 \$908 CLK|X HI|VPB|VPWR HI|VPB|VPWR sky130_fd_pr__pfet_01v8_hvt L=0.15
+ W=0.64 AS=0.1664 AD=0.0864 PS=1.8 PD=0.91
M$679 HI|VPB|VPWR \$908 \$909 HI|VPB|VPWR sky130_fd_pr__pfet_01v8_hvt L=0.15
+ W=0.64 AS=0.0864 AD=0.1664 PS=0.91 PD=1.8
M$680 HI|VPB|VPWR D|X \$910 HI|VPB|VPWR sky130_fd_pr__pfet_01v8_hvt L=0.15
+ W=0.42 AS=0.1092 AD=0.0651 PS=1.36 PD=0.73
M$681 \$910 \$909 \$911 HI|VPB|VPWR sky130_fd_pr__pfet_01v8_hvt L=0.15 W=0.42
+ AS=0.0651 AD=0.07245 PS=0.73 PD=0.765
M$682 \$911 \$908 \$912 HI|VPB|VPWR sky130_fd_pr__pfet_01v8_hvt L=0.15 W=0.42
+ AS=0.07245 AD=0.1155 PS=0.765 PD=0.97
M$683 \$912 \$913 HI|VPB|VPWR HI|VPB|VPWR sky130_fd_pr__pfet_01v8_hvt L=0.15
+ W=0.42 AS=0.1155 AD=0.07035 PS=0.97 PD=0.755
M$684 HI|VPB|VPWR PRESETn|RESET_B \$912 HI|VPB|VPWR sky130_fd_pr__pfet_01v8_hvt
+ L=0.15 W=0.42 AS=0.07035 AD=0.1092 PS=0.755 PD=1.36
M$685 \$913 \$908 \$914 HI|VPB|VPWR sky130_fd_pr__pfet_01v8_hvt L=0.15 W=0.42
+ AS=0.12915 AD=0.0588 PS=1.185 PD=0.7
M$686 \$914 \$909 \$925 HI|VPB|VPWR sky130_fd_pr__pfet_01v8_hvt L=0.15 W=0.42
+ AS=0.0588 AD=0.0567 PS=0.7 PD=0.69
M$687 \$925 \$915 HI|VPB|VPWR HI|VPB|VPWR sky130_fd_pr__pfet_01v8_hvt L=0.15
+ W=0.42 AS=0.0567 AD=0.0819 PS=0.69 PD=0.81
M$688 HI|VPB|VPWR PRESETn|RESET_B \$915 HI|VPB|VPWR sky130_fd_pr__pfet_01v8_hvt
+ L=0.15 W=0.42 AS=0.0819 AD=0.0567 PS=0.81 PD=0.69
M$689 \$915 \$914 HI|VPB|VPWR HI|VPB|VPWR sky130_fd_pr__pfet_01v8_hvt L=0.15
+ W=0.42 AS=0.0567 AD=0.1134 PS=0.69 PD=1.38
M$690 HI|VPB|VPWR \$911 \$913 HI|VPB|VPWR sky130_fd_pr__pfet_01v8_hvt L=0.15
+ W=0.84 AS=0.2184 AD=0.12915 PS=2.2 PD=1.185
M$691 HI|VPB|VPWR \$915 A0|C1|Q|gpio_out[7] HI|VPB|VPWR
+ sky130_fd_pr__pfet_01v8_hvt L=0.15 W=1 AS=0.3012 AD=0.26 PS=2.66 PD=2.52
M$692 B|Y A0|C1|Q|gpio_out[7] \$916 HI|VPB|VPWR sky130_fd_pr__pfet_01v8_hvt
+ L=0.15 W=1 AS=0.26 AD=0.135 PS=2.52 PD=1.27
M$693 \$916 A2|B|C2|Y B|Y HI|VPB|VPWR sky130_fd_pr__pfet_01v8_hvt L=0.15 W=1
+ AS=0.135 AD=0.26 PS=1.27 PD=2.52
M$694 \$917 A0|B2|Q|gpio_oe[7] \$916 HI|VPB|VPWR sky130_fd_pr__pfet_01v8_hvt
+ L=0.15 W=1 AS=0.26 AD=0.135 PS=2.52 PD=1.27
M$695 \$916 B|B1|B_N|Y \$917 HI|VPB|VPWR sky130_fd_pr__pfet_01v8_hvt L=0.15 W=1
+ AS=0.135 AD=0.135 PS=1.27 PD=1.27
M$696 \$917 A1|gpio_in[7] HI|VPB|VPWR HI|VPB|VPWR sky130_fd_pr__pfet_01v8_hvt
+ L=0.15 W=1 AS=0.135 AD=0.165 PS=1.27 PD=1.33
M$697 HI|VPB|VPWR A2|B1|Y \$917 HI|VPB|VPWR sky130_fd_pr__pfet_01v8_hvt L=0.15
+ W=1 AS=0.165 AD=0.26 PS=1.33 PD=2.52
M$698 HI|VPB|VPWR S|X \$926 HI|VPB|VPWR sky130_fd_pr__pfet_01v8_hvt L=0.15
+ W=0.42 AS=0.15835 AD=0.07665 PS=1.395 PD=0.785
M$699 \$926 A0|B2|Q|gpio_oe[5] \$918 HI|VPB|VPWR sky130_fd_pr__pfet_01v8_hvt
+ L=0.15 W=0.42 AS=0.07665 AD=0.1932 PS=0.785 PD=1.34
M$700 \$918 A1|PWDATA[5] \$927 HI|VPB|VPWR sky130_fd_pr__pfet_01v8_hvt L=0.15
+ W=0.42 AS=0.1932 AD=0.0441 PS=1.34 PD=0.63
M$701 \$927 \$919 HI|VPB|VPWR HI|VPB|VPWR sky130_fd_pr__pfet_01v8_hvt L=0.15
+ W=0.42 AS=0.0441 AD=0.0693 PS=0.63 PD=0.75
M$702 HI|VPB|VPWR S|X \$919 HI|VPB|VPWR sky130_fd_pr__pfet_01v8_hvt L=0.15
+ W=0.42 AS=0.0693 AD=0.1176 PS=0.75 PD=1.4
M$703 A|X \$918 HI|VPB|VPWR HI|VPB|VPWR sky130_fd_pr__pfet_01v8_hvt L=0.15 W=1
+ AS=0.26 AD=0.15835 PS=2.52 PD=1.395
M$704 B|Y A0|C1|Q|gpio_out[5] \$921 HI|VPB|VPWR sky130_fd_pr__pfet_01v8_hvt
+ L=0.15 W=1 AS=0.26 AD=0.135 PS=2.52 PD=1.27
M$705 \$921 A2|B|C2|Y B|Y HI|VPB|VPWR sky130_fd_pr__pfet_01v8_hvt L=0.15 W=1
+ AS=0.135 AD=0.26 PS=1.27 PD=2.52
M$706 \$922 A0|B2|Q|gpio_oe[5] \$921 HI|VPB|VPWR sky130_fd_pr__pfet_01v8_hvt
+ L=0.15 W=1 AS=0.26 AD=0.135 PS=2.52 PD=1.27
M$707 \$921 B|B1|B_N|Y \$922 HI|VPB|VPWR sky130_fd_pr__pfet_01v8_hvt L=0.15 W=1
+ AS=0.135 AD=0.135 PS=1.27 PD=1.27
M$708 \$922 A1|gpio_in[5] HI|VPB|VPWR HI|VPB|VPWR sky130_fd_pr__pfet_01v8_hvt
+ L=0.15 W=1 AS=0.135 AD=0.165 PS=1.27 PD=1.33
M$709 HI|VPB|VPWR A2|B1|Y \$922 HI|VPB|VPWR sky130_fd_pr__pfet_01v8_hvt L=0.15
+ W=1 AS=0.165 AD=0.26 PS=1.33 PD=2.52
M$710 A2|Y B2|gpio_in[4] \$923 HI|VPB|VPWR sky130_fd_pr__pfet_01v8_hvt L=0.15
+ W=1 AS=0.26 AD=0.135 PS=2.52 PD=1.27
M$711 \$923 A2|B1|Y A2|Y HI|VPB|VPWR sky130_fd_pr__pfet_01v8_hvt L=0.15 W=1
+ AS=0.135 AD=0.26 PS=1.27 PD=2.52
M$712 HI|VPB|VPWR A0|A1|Q|gpio_out[4] \$923 HI|VPB|VPWR
+ sky130_fd_pr__pfet_01v8_hvt L=0.15 W=1 AS=0.26 AD=0.135 PS=2.52 PD=1.27
M$713 \$923 A2|B|C2|Y HI|VPB|VPWR HI|VPB|VPWR sky130_fd_pr__pfet_01v8_hvt
+ L=0.15 W=1 AS=0.135 AD=0.3 PS=1.27 PD=2.6
M$714 HI|VPB|VPWR A|X \$924 HI|VPB|VPWR sky130_fd_pr__pfet_01v8_hvt L=0.15 W=2
+ AS=0.395 AD=0.27 PS=3.79 PD=2.54
M$716 HI|VPB|VPWR \$924 D|X HI|VPB|VPWR sky130_fd_pr__pfet_01v8_hvt L=0.15 W=6
+ AS=0.81 AD=0.935 PS=7.62 PD=8.87
M$722 \$951 A|X HI|VPB|VPWR HI|VPB|VPWR sky130_fd_pr__pfet_01v8_hvt L=0.15 W=2
+ AS=0.415 AD=0.27 PS=3.83 PD=2.54
M$724 \$951 B|Y PRDATA[7]|Y HI|VPB|VPWR sky130_fd_pr__pfet_01v8_hvt L=0.15 W=2
+ AS=0.27 AD=0.395 PS=2.54 PD=3.79
M$726 \$953 A|X HI|VPB|VPWR HI|VPB|VPWR sky130_fd_pr__pfet_01v8_hvt L=0.15 W=2
+ AS=0.415 AD=0.27 PS=3.83 PD=2.54
M$728 \$953 B|Y PRDATA[5]|Y HI|VPB|VPWR sky130_fd_pr__pfet_01v8_hvt L=0.15 W=2
+ AS=0.27 AD=0.395 PS=2.54 PD=3.79
M$730
+ LO|PRDATA[10]|PRDATA[12]|PRDATA[13]|PRDATA[15]|PRDATA[16]|PRDATA[17]|PRDATA[18]|PRDATA[19]|PRDATA[21]|PRDATA[23]|PRDATA[27]|PRDATA[28]|PRDATA[29]|PRDATA[31]|PRDATA[9]|PSLVERR|VGND
+ S|X \$48
+ LO|PRDATA[10]|PRDATA[12]|PRDATA[13]|PRDATA[15]|PRDATA[16]|PRDATA[17]|PRDATA[18]|PRDATA[19]|PRDATA[21]|PRDATA[23]|PRDATA[27]|PRDATA[28]|PRDATA[29]|PRDATA[31]|PRDATA[9]|PSLVERR|VGND
+ sky130_fd_pr__nfet_01v8 L=0.15 W=0.42 AS=0.11285 AD=0.0693 PS=1.045 PD=0.75
M$731 \$48 A1|PWDATA[0] \$32
+ LO|PRDATA[10]|PRDATA[12]|PRDATA[13]|PRDATA[15]|PRDATA[16]|PRDATA[17]|PRDATA[18]|PRDATA[19]|PRDATA[21]|PRDATA[23]|PRDATA[27]|PRDATA[28]|PRDATA[29]|PRDATA[31]|PRDATA[9]|PSLVERR|VGND
+ sky130_fd_pr__nfet_01v8 L=0.15 W=0.42 AS=0.0693 AD=0.09975 PS=0.75 PD=0.895
M$732 \$32 A0|B2|Q|gpio_oe[0] \$50
+ LO|PRDATA[10]|PRDATA[12]|PRDATA[13]|PRDATA[15]|PRDATA[16]|PRDATA[17]|PRDATA[18]|PRDATA[19]|PRDATA[21]|PRDATA[23]|PRDATA[27]|PRDATA[28]|PRDATA[29]|PRDATA[31]|PRDATA[9]|PSLVERR|VGND
+ sky130_fd_pr__nfet_01v8 L=0.15 W=0.42 AS=0.09975 AD=0.0693 PS=0.895 PD=0.75
M$733 \$50 \$35
+ LO|PRDATA[10]|PRDATA[12]|PRDATA[13]|PRDATA[15]|PRDATA[16]|PRDATA[17]|PRDATA[18]|PRDATA[19]|PRDATA[21]|PRDATA[23]|PRDATA[27]|PRDATA[28]|PRDATA[29]|PRDATA[31]|PRDATA[9]|PSLVERR|VGND
+ LO|PRDATA[10]|PRDATA[12]|PRDATA[13]|PRDATA[15]|PRDATA[16]|PRDATA[17]|PRDATA[18]|PRDATA[19]|PRDATA[21]|PRDATA[23]|PRDATA[27]|PRDATA[28]|PRDATA[29]|PRDATA[31]|PRDATA[9]|PSLVERR|VGND
+ sky130_fd_pr__nfet_01v8 L=0.15 W=0.42 AS=0.0693 AD=0.1449 PS=0.75 PD=1.11
M$734
+ LO|PRDATA[10]|PRDATA[12]|PRDATA[13]|PRDATA[15]|PRDATA[16]|PRDATA[17]|PRDATA[18]|PRDATA[19]|PRDATA[21]|PRDATA[23]|PRDATA[27]|PRDATA[28]|PRDATA[29]|PRDATA[31]|PRDATA[9]|PSLVERR|VGND
+ S|X \$35
+ LO|PRDATA[10]|PRDATA[12]|PRDATA[13]|PRDATA[15]|PRDATA[16]|PRDATA[17]|PRDATA[18]|PRDATA[19]|PRDATA[21]|PRDATA[23]|PRDATA[27]|PRDATA[28]|PRDATA[29]|PRDATA[31]|PRDATA[9]|PSLVERR|VGND
+ sky130_fd_pr__nfet_01v8 L=0.15 W=0.42 AS=0.1449 AD=0.1092 PS=1.11 PD=1.36
M$735 A|X \$32
+ LO|PRDATA[10]|PRDATA[12]|PRDATA[13]|PRDATA[15]|PRDATA[16]|PRDATA[17]|PRDATA[18]|PRDATA[19]|PRDATA[21]|PRDATA[23]|PRDATA[27]|PRDATA[28]|PRDATA[29]|PRDATA[31]|PRDATA[9]|PSLVERR|VGND
+ LO|PRDATA[10]|PRDATA[12]|PRDATA[13]|PRDATA[15]|PRDATA[16]|PRDATA[17]|PRDATA[18]|PRDATA[19]|PRDATA[21]|PRDATA[23]|PRDATA[27]|PRDATA[28]|PRDATA[29]|PRDATA[31]|PRDATA[9]|PSLVERR|VGND
+ sky130_fd_pr__nfet_01v8 L=0.15 W=0.65 AS=0.169 AD=0.11285 PS=1.82 PD=1.045
M$736 \$37 A1|gpio_in[6]
+ LO|PRDATA[10]|PRDATA[12]|PRDATA[13]|PRDATA[15]|PRDATA[16]|PRDATA[17]|PRDATA[18]|PRDATA[19]|PRDATA[21]|PRDATA[23]|PRDATA[27]|PRDATA[28]|PRDATA[29]|PRDATA[31]|PRDATA[9]|PSLVERR|VGND
+ LO|PRDATA[10]|PRDATA[12]|PRDATA[13]|PRDATA[15]|PRDATA[16]|PRDATA[17]|PRDATA[18]|PRDATA[19]|PRDATA[21]|PRDATA[23]|PRDATA[27]|PRDATA[28]|PRDATA[29]|PRDATA[31]|PRDATA[9]|PSLVERR|VGND
+ sky130_fd_pr__nfet_01v8 L=0.15 W=0.42 AS=0.1113 AD=0.0588 PS=1.37 PD=0.7
M$737
+ LO|PRDATA[10]|PRDATA[12]|PRDATA[13]|PRDATA[15]|PRDATA[16]|PRDATA[17]|PRDATA[18]|PRDATA[19]|PRDATA[21]|PRDATA[23]|PRDATA[27]|PRDATA[28]|PRDATA[29]|PRDATA[31]|PRDATA[9]|PSLVERR|VGND
+ A|A2|C|D_N|X \$37
+ LO|PRDATA[10]|PRDATA[12]|PRDATA[13]|PRDATA[15]|PRDATA[16]|PRDATA[17]|PRDATA[18]|PRDATA[19]|PRDATA[21]|PRDATA[23]|PRDATA[27]|PRDATA[28]|PRDATA[29]|PRDATA[31]|PRDATA[9]|PSLVERR|VGND
+ sky130_fd_pr__nfet_01v8 L=0.15 W=0.42 AS=0.0588 AD=0.0588 PS=0.7 PD=0.7
M$738 \$37 B|B1|Y A1|Y
+ LO|PRDATA[10]|PRDATA[12]|PRDATA[13]|PRDATA[15]|PRDATA[16]|PRDATA[17]|PRDATA[18]|PRDATA[19]|PRDATA[21]|PRDATA[23]|PRDATA[27]|PRDATA[28]|PRDATA[29]|PRDATA[31]|PRDATA[9]|PSLVERR|VGND
+ sky130_fd_pr__nfet_01v8 L=0.15 W=0.42 AS=0.0588 AD=0.1113 PS=0.7 PD=1.37
M$739
+ LO|PRDATA[10]|PRDATA[12]|PRDATA[13]|PRDATA[15]|PRDATA[16]|PRDATA[17]|PRDATA[18]|PRDATA[19]|PRDATA[21]|PRDATA[23]|PRDATA[27]|PRDATA[28]|PRDATA[29]|PRDATA[31]|PRDATA[9]|PSLVERR|VGND
+ A|X \$40
+ LO|PRDATA[10]|PRDATA[12]|PRDATA[13]|PRDATA[15]|PRDATA[16]|PRDATA[17]|PRDATA[18]|PRDATA[19]|PRDATA[21]|PRDATA[23]|PRDATA[27]|PRDATA[28]|PRDATA[29]|PRDATA[31]|PRDATA[9]|PSLVERR|VGND
+ sky130_fd_pr__nfet_01v8 L=0.15 W=1.3 AS=0.25675 AD=0.1755 PS=2.74 PD=1.84
M$741
+ LO|PRDATA[10]|PRDATA[12]|PRDATA[13]|PRDATA[15]|PRDATA[16]|PRDATA[17]|PRDATA[18]|PRDATA[19]|PRDATA[21]|PRDATA[23]|PRDATA[27]|PRDATA[28]|PRDATA[29]|PRDATA[31]|PRDATA[9]|PSLVERR|VGND
+ \$40 D|X
+ LO|PRDATA[10]|PRDATA[12]|PRDATA[13]|PRDATA[15]|PRDATA[16]|PRDATA[17]|PRDATA[18]|PRDATA[19]|PRDATA[21]|PRDATA[23]|PRDATA[27]|PRDATA[28]|PRDATA[29]|PRDATA[31]|PRDATA[9]|PSLVERR|VGND
+ sky130_fd_pr__nfet_01v8 L=0.15 W=3.9 AS=0.5265 AD=0.60775 PS=5.52 PD=6.42
M$747
+ LO|PRDATA[10]|PRDATA[12]|PRDATA[13]|PRDATA[15]|PRDATA[16]|PRDATA[17]|PRDATA[18]|PRDATA[19]|PRDATA[21]|PRDATA[23]|PRDATA[27]|PRDATA[28]|PRDATA[29]|PRDATA[31]|PRDATA[9]|PSLVERR|VGND
+ \$85 A0|B2|Q|gpio_oe[0]
+ LO|PRDATA[10]|PRDATA[12]|PRDATA[13]|PRDATA[15]|PRDATA[16]|PRDATA[17]|PRDATA[18]|PRDATA[19]|PRDATA[21]|PRDATA[23]|PRDATA[27]|PRDATA[28]|PRDATA[29]|PRDATA[31]|PRDATA[9]|PSLVERR|VGND
+ sky130_fd_pr__nfet_01v8 L=0.15 W=0.65 AS=0.2087 AD=0.169 PS=2.02 PD=1.82
M$748
+ LO|PRDATA[10]|PRDATA[12]|PRDATA[13]|PRDATA[15]|PRDATA[16]|PRDATA[17]|PRDATA[18]|PRDATA[19]|PRDATA[21]|PRDATA[23]|PRDATA[27]|PRDATA[28]|PRDATA[29]|PRDATA[31]|PRDATA[9]|PSLVERR|VGND
+ A2|Y \$125
+ LO|PRDATA[10]|PRDATA[12]|PRDATA[13]|PRDATA[15]|PRDATA[16]|PRDATA[17]|PRDATA[18]|PRDATA[19]|PRDATA[21]|PRDATA[23]|PRDATA[27]|PRDATA[28]|PRDATA[29]|PRDATA[31]|PRDATA[9]|PSLVERR|VGND
+ sky130_fd_pr__nfet_01v8 L=0.15 W=0.65 AS=0.18525 AD=0.089375 PS=1.87 PD=0.925
M$749 \$125 A1|Y PRDATA[0]|Y
+ LO|PRDATA[10]|PRDATA[12]|PRDATA[13]|PRDATA[15]|PRDATA[16]|PRDATA[17]|PRDATA[18]|PRDATA[19]|PRDATA[21]|PRDATA[23]|PRDATA[27]|PRDATA[28]|PRDATA[29]|PRDATA[31]|PRDATA[9]|PSLVERR|VGND
+ sky130_fd_pr__nfet_01v8 L=0.15 W=0.65 AS=0.089375 AD=0.091 PS=0.925 PD=0.93
M$750 PRDATA[0]|Y A1|Y \$128
+ LO|PRDATA[10]|PRDATA[12]|PRDATA[13]|PRDATA[15]|PRDATA[16]|PRDATA[17]|PRDATA[18]|PRDATA[19]|PRDATA[21]|PRDATA[23]|PRDATA[27]|PRDATA[28]|PRDATA[29]|PRDATA[31]|PRDATA[9]|PSLVERR|VGND
+ sky130_fd_pr__nfet_01v8 L=0.15 W=0.65 AS=0.091 AD=0.06825 PS=0.93 PD=0.86
M$751 \$128 A2|Y
+ LO|PRDATA[10]|PRDATA[12]|PRDATA[13]|PRDATA[15]|PRDATA[16]|PRDATA[17]|PRDATA[18]|PRDATA[19]|PRDATA[21]|PRDATA[23]|PRDATA[27]|PRDATA[28]|PRDATA[29]|PRDATA[31]|PRDATA[9]|PSLVERR|VGND
+ LO|PRDATA[10]|PRDATA[12]|PRDATA[13]|PRDATA[15]|PRDATA[16]|PRDATA[17]|PRDATA[18]|PRDATA[19]|PRDATA[21]|PRDATA[23]|PRDATA[27]|PRDATA[28]|PRDATA[29]|PRDATA[31]|PRDATA[9]|PSLVERR|VGND
+ sky130_fd_pr__nfet_01v8 L=0.15 W=0.65 AS=0.06825 AD=0.10725 PS=0.86 PD=0.98
M$752
+ LO|PRDATA[10]|PRDATA[12]|PRDATA[13]|PRDATA[15]|PRDATA[16]|PRDATA[17]|PRDATA[18]|PRDATA[19]|PRDATA[21]|PRDATA[23]|PRDATA[27]|PRDATA[28]|PRDATA[29]|PRDATA[31]|PRDATA[9]|PSLVERR|VGND
+ A|B1|X PRDATA[0]|Y
+ LO|PRDATA[10]|PRDATA[12]|PRDATA[13]|PRDATA[15]|PRDATA[16]|PRDATA[17]|PRDATA[18]|PRDATA[19]|PRDATA[21]|PRDATA[23]|PRDATA[27]|PRDATA[28]|PRDATA[29]|PRDATA[31]|PRDATA[9]|PSLVERR|VGND
+ sky130_fd_pr__nfet_01v8 L=0.15 W=1.3 AS=0.195 AD=0.34775 PS=1.9 PD=3.02
M$754
+ LO|PRDATA[10]|PRDATA[12]|PRDATA[13]|PRDATA[15]|PRDATA[16]|PRDATA[17]|PRDATA[18]|PRDATA[19]|PRDATA[21]|PRDATA[23]|PRDATA[27]|PRDATA[28]|PRDATA[29]|PRDATA[31]|PRDATA[9]|PSLVERR|VGND
+ A2|Y \$129
+ LO|PRDATA[10]|PRDATA[12]|PRDATA[13]|PRDATA[15]|PRDATA[16]|PRDATA[17]|PRDATA[18]|PRDATA[19]|PRDATA[21]|PRDATA[23]|PRDATA[27]|PRDATA[28]|PRDATA[29]|PRDATA[31]|PRDATA[9]|PSLVERR|VGND
+ sky130_fd_pr__nfet_01v8 L=0.15 W=0.65 AS=0.18525 AD=0.089375 PS=1.87 PD=0.925
M$755 \$129 A1|Y PRDATA[6]|Y
+ LO|PRDATA[10]|PRDATA[12]|PRDATA[13]|PRDATA[15]|PRDATA[16]|PRDATA[17]|PRDATA[18]|PRDATA[19]|PRDATA[21]|PRDATA[23]|PRDATA[27]|PRDATA[28]|PRDATA[29]|PRDATA[31]|PRDATA[9]|PSLVERR|VGND
+ sky130_fd_pr__nfet_01v8 L=0.15 W=0.65 AS=0.089375 AD=0.091 PS=0.925 PD=0.93
M$756 PRDATA[6]|Y A1|Y \$131
+ LO|PRDATA[10]|PRDATA[12]|PRDATA[13]|PRDATA[15]|PRDATA[16]|PRDATA[17]|PRDATA[18]|PRDATA[19]|PRDATA[21]|PRDATA[23]|PRDATA[27]|PRDATA[28]|PRDATA[29]|PRDATA[31]|PRDATA[9]|PSLVERR|VGND
+ sky130_fd_pr__nfet_01v8 L=0.15 W=0.65 AS=0.091 AD=0.06825 PS=0.93 PD=0.86
M$757 \$131 A2|Y
+ LO|PRDATA[10]|PRDATA[12]|PRDATA[13]|PRDATA[15]|PRDATA[16]|PRDATA[17]|PRDATA[18]|PRDATA[19]|PRDATA[21]|PRDATA[23]|PRDATA[27]|PRDATA[28]|PRDATA[29]|PRDATA[31]|PRDATA[9]|PSLVERR|VGND
+ LO|PRDATA[10]|PRDATA[12]|PRDATA[13]|PRDATA[15]|PRDATA[16]|PRDATA[17]|PRDATA[18]|PRDATA[19]|PRDATA[21]|PRDATA[23]|PRDATA[27]|PRDATA[28]|PRDATA[29]|PRDATA[31]|PRDATA[9]|PSLVERR|VGND
+ sky130_fd_pr__nfet_01v8 L=0.15 W=0.65 AS=0.06825 AD=0.10725 PS=0.86 PD=0.98
M$758
+ LO|PRDATA[10]|PRDATA[12]|PRDATA[13]|PRDATA[15]|PRDATA[16]|PRDATA[17]|PRDATA[18]|PRDATA[19]|PRDATA[21]|PRDATA[23]|PRDATA[27]|PRDATA[28]|PRDATA[29]|PRDATA[31]|PRDATA[9]|PSLVERR|VGND
+ A|B1|X PRDATA[6]|Y
+ LO|PRDATA[10]|PRDATA[12]|PRDATA[13]|PRDATA[15]|PRDATA[16]|PRDATA[17]|PRDATA[18]|PRDATA[19]|PRDATA[21]|PRDATA[23]|PRDATA[27]|PRDATA[28]|PRDATA[29]|PRDATA[31]|PRDATA[9]|PSLVERR|VGND
+ sky130_fd_pr__nfet_01v8 L=0.15 W=1.3 AS=0.195 AD=0.34775 PS=1.9 PD=3.02
M$760
+ LO|PRDATA[10]|PRDATA[12]|PRDATA[13]|PRDATA[15]|PRDATA[16]|PRDATA[17]|PRDATA[18]|PRDATA[19]|PRDATA[21]|PRDATA[23]|PRDATA[27]|PRDATA[28]|PRDATA[29]|PRDATA[31]|PRDATA[9]|PSLVERR|VGND
+ A|PADDR[2] \$91
+ LO|PRDATA[10]|PRDATA[12]|PRDATA[13]|PRDATA[15]|PRDATA[16]|PRDATA[17]|PRDATA[18]|PRDATA[19]|PRDATA[21]|PRDATA[23]|PRDATA[27]|PRDATA[28]|PRDATA[29]|PRDATA[31]|PRDATA[9]|PSLVERR|VGND
+ sky130_fd_pr__nfet_01v8 L=0.15 W=0.42 AS=0.097 AD=0.1092 PS=0.975 PD=1.36
M$761
+ LO|PRDATA[10]|PRDATA[12]|PRDATA[13]|PRDATA[15]|PRDATA[16]|PRDATA[17]|PRDATA[18]|PRDATA[19]|PRDATA[21]|PRDATA[23]|PRDATA[27]|PRDATA[28]|PRDATA[29]|PRDATA[31]|PRDATA[9]|PSLVERR|VGND
+ \$91 A|A2|C|D_N|X
+ LO|PRDATA[10]|PRDATA[12]|PRDATA[13]|PRDATA[15]|PRDATA[16]|PRDATA[17]|PRDATA[18]|PRDATA[19]|PRDATA[21]|PRDATA[23]|PRDATA[27]|PRDATA[28]|PRDATA[29]|PRDATA[31]|PRDATA[9]|PSLVERR|VGND
+ sky130_fd_pr__nfet_01v8 L=0.15 W=1.3 AS=0.18475 AD=0.26 PS=1.895 PD=2.75
M$763
+ LO|PRDATA[10]|PRDATA[12]|PRDATA[13]|PRDATA[15]|PRDATA[16]|PRDATA[17]|PRDATA[18]|PRDATA[19]|PRDATA[21]|PRDATA[23]|PRDATA[27]|PRDATA[28]|PRDATA[29]|PRDATA[31]|PRDATA[9]|PSLVERR|VGND
+ A2|Y \$132
+ LO|PRDATA[10]|PRDATA[12]|PRDATA[13]|PRDATA[15]|PRDATA[16]|PRDATA[17]|PRDATA[18]|PRDATA[19]|PRDATA[21]|PRDATA[23]|PRDATA[27]|PRDATA[28]|PRDATA[29]|PRDATA[31]|PRDATA[9]|PSLVERR|VGND
+ sky130_fd_pr__nfet_01v8 L=0.15 W=0.65 AS=0.18525 AD=0.089375 PS=1.87 PD=0.925
M$764 \$132 A1|Y PRDATA[1]|Y
+ LO|PRDATA[10]|PRDATA[12]|PRDATA[13]|PRDATA[15]|PRDATA[16]|PRDATA[17]|PRDATA[18]|PRDATA[19]|PRDATA[21]|PRDATA[23]|PRDATA[27]|PRDATA[28]|PRDATA[29]|PRDATA[31]|PRDATA[9]|PSLVERR|VGND
+ sky130_fd_pr__nfet_01v8 L=0.15 W=0.65 AS=0.089375 AD=0.091 PS=0.925 PD=0.93
M$765 PRDATA[1]|Y A1|Y \$130
+ LO|PRDATA[10]|PRDATA[12]|PRDATA[13]|PRDATA[15]|PRDATA[16]|PRDATA[17]|PRDATA[18]|PRDATA[19]|PRDATA[21]|PRDATA[23]|PRDATA[27]|PRDATA[28]|PRDATA[29]|PRDATA[31]|PRDATA[9]|PSLVERR|VGND
+ sky130_fd_pr__nfet_01v8 L=0.15 W=0.65 AS=0.091 AD=0.06825 PS=0.93 PD=0.86
M$766 \$130 A2|Y
+ LO|PRDATA[10]|PRDATA[12]|PRDATA[13]|PRDATA[15]|PRDATA[16]|PRDATA[17]|PRDATA[18]|PRDATA[19]|PRDATA[21]|PRDATA[23]|PRDATA[27]|PRDATA[28]|PRDATA[29]|PRDATA[31]|PRDATA[9]|PSLVERR|VGND
+ LO|PRDATA[10]|PRDATA[12]|PRDATA[13]|PRDATA[15]|PRDATA[16]|PRDATA[17]|PRDATA[18]|PRDATA[19]|PRDATA[21]|PRDATA[23]|PRDATA[27]|PRDATA[28]|PRDATA[29]|PRDATA[31]|PRDATA[9]|PSLVERR|VGND
+ sky130_fd_pr__nfet_01v8 L=0.15 W=0.65 AS=0.06825 AD=0.10725 PS=0.86 PD=0.98
M$767
+ LO|PRDATA[10]|PRDATA[12]|PRDATA[13]|PRDATA[15]|PRDATA[16]|PRDATA[17]|PRDATA[18]|PRDATA[19]|PRDATA[21]|PRDATA[23]|PRDATA[27]|PRDATA[28]|PRDATA[29]|PRDATA[31]|PRDATA[9]|PSLVERR|VGND
+ A|B1|X PRDATA[1]|Y
+ LO|PRDATA[10]|PRDATA[12]|PRDATA[13]|PRDATA[15]|PRDATA[16]|PRDATA[17]|PRDATA[18]|PRDATA[19]|PRDATA[21]|PRDATA[23]|PRDATA[27]|PRDATA[28]|PRDATA[29]|PRDATA[31]|PRDATA[9]|PSLVERR|VGND
+ sky130_fd_pr__nfet_01v8 L=0.15 W=1.3 AS=0.195 AD=0.34775 PS=1.9 PD=3.02
M$769
+ LO|PRDATA[10]|PRDATA[12]|PRDATA[13]|PRDATA[15]|PRDATA[16]|PRDATA[17]|PRDATA[18]|PRDATA[19]|PRDATA[21]|PRDATA[23]|PRDATA[27]|PRDATA[28]|PRDATA[29]|PRDATA[31]|PRDATA[9]|PSLVERR|VGND
+ \$100 A0|B2|Q|gpio_oe[3]
+ LO|PRDATA[10]|PRDATA[12]|PRDATA[13]|PRDATA[15]|PRDATA[16]|PRDATA[17]|PRDATA[18]|PRDATA[19]|PRDATA[21]|PRDATA[23]|PRDATA[27]|PRDATA[28]|PRDATA[29]|PRDATA[31]|PRDATA[9]|PSLVERR|VGND
+ sky130_fd_pr__nfet_01v8 L=0.15 W=0.65 AS=0.2087 AD=0.169 PS=2.02 PD=1.82
M$770 \$79 CLK|X
+ LO|PRDATA[10]|PRDATA[12]|PRDATA[13]|PRDATA[15]|PRDATA[16]|PRDATA[17]|PRDATA[18]|PRDATA[19]|PRDATA[21]|PRDATA[23]|PRDATA[27]|PRDATA[28]|PRDATA[29]|PRDATA[31]|PRDATA[9]|PSLVERR|VGND
+ LO|PRDATA[10]|PRDATA[12]|PRDATA[13]|PRDATA[15]|PRDATA[16]|PRDATA[17]|PRDATA[18]|PRDATA[19]|PRDATA[21]|PRDATA[23]|PRDATA[27]|PRDATA[28]|PRDATA[29]|PRDATA[31]|PRDATA[9]|PSLVERR|VGND
+ sky130_fd_pr__nfet_01v8 L=0.15 W=0.42 AS=0.1092 AD=0.0567 PS=1.36 PD=0.69
M$771
+ LO|PRDATA[10]|PRDATA[12]|PRDATA[13]|PRDATA[15]|PRDATA[16]|PRDATA[17]|PRDATA[18]|PRDATA[19]|PRDATA[21]|PRDATA[23]|PRDATA[27]|PRDATA[28]|PRDATA[29]|PRDATA[31]|PRDATA[9]|PSLVERR|VGND
+ \$79 \$80
+ LO|PRDATA[10]|PRDATA[12]|PRDATA[13]|PRDATA[15]|PRDATA[16]|PRDATA[17]|PRDATA[18]|PRDATA[19]|PRDATA[21]|PRDATA[23]|PRDATA[27]|PRDATA[28]|PRDATA[29]|PRDATA[31]|PRDATA[9]|PSLVERR|VGND
+ sky130_fd_pr__nfet_01v8 L=0.15 W=0.42 AS=0.0567 AD=0.1092 PS=0.69 PD=1.36
M$772
+ LO|PRDATA[10]|PRDATA[12]|PRDATA[13]|PRDATA[15]|PRDATA[16]|PRDATA[17]|PRDATA[18]|PRDATA[19]|PRDATA[21]|PRDATA[23]|PRDATA[27]|PRDATA[28]|PRDATA[29]|PRDATA[31]|PRDATA[9]|PSLVERR|VGND
+ D|X \$81
+ LO|PRDATA[10]|PRDATA[12]|PRDATA[13]|PRDATA[15]|PRDATA[16]|PRDATA[17]|PRDATA[18]|PRDATA[19]|PRDATA[21]|PRDATA[23]|PRDATA[27]|PRDATA[28]|PRDATA[29]|PRDATA[31]|PRDATA[9]|PSLVERR|VGND
+ sky130_fd_pr__nfet_01v8 L=0.15 W=0.42 AS=0.2205 AD=0.066 PS=1.89 PD=0.745
M$773 \$81 \$79 \$82
+ LO|PRDATA[10]|PRDATA[12]|PRDATA[13]|PRDATA[15]|PRDATA[16]|PRDATA[17]|PRDATA[18]|PRDATA[19]|PRDATA[21]|PRDATA[23]|PRDATA[27]|PRDATA[28]|PRDATA[29]|PRDATA[31]|PRDATA[9]|PSLVERR|VGND
+ sky130_fd_pr__nfet_01v8 L=0.15 W=0.36 AS=0.066 AD=0.0594 PS=0.745 PD=0.69
M$774 \$119 \$80 \$82
+ LO|PRDATA[10]|PRDATA[12]|PRDATA[13]|PRDATA[15]|PRDATA[16]|PRDATA[17]|PRDATA[18]|PRDATA[19]|PRDATA[21]|PRDATA[23]|PRDATA[27]|PRDATA[28]|PRDATA[29]|PRDATA[31]|PRDATA[9]|PSLVERR|VGND
+ sky130_fd_pr__nfet_01v8 L=0.15 W=0.36 AS=0.1401 AD=0.0594 PS=1.1 PD=0.69
M$775 \$119 \$105 \$120
+ LO|PRDATA[10]|PRDATA[12]|PRDATA[13]|PRDATA[15]|PRDATA[16]|PRDATA[17]|PRDATA[18]|PRDATA[19]|PRDATA[21]|PRDATA[23]|PRDATA[27]|PRDATA[28]|PRDATA[29]|PRDATA[31]|PRDATA[9]|PSLVERR|VGND
+ sky130_fd_pr__nfet_01v8 L=0.15 W=0.42 AS=0.1401 AD=0.0441 PS=1.1 PD=0.63
M$776
+ LO|PRDATA[10]|PRDATA[12]|PRDATA[13]|PRDATA[15]|PRDATA[16]|PRDATA[17]|PRDATA[18]|PRDATA[19]|PRDATA[21]|PRDATA[23]|PRDATA[27]|PRDATA[28]|PRDATA[29]|PRDATA[31]|PRDATA[9]|PSLVERR|VGND
+ PRESETn|RESET_B \$120
+ LO|PRDATA[10]|PRDATA[12]|PRDATA[13]|PRDATA[15]|PRDATA[16]|PRDATA[17]|PRDATA[18]|PRDATA[19]|PRDATA[21]|PRDATA[23]|PRDATA[27]|PRDATA[28]|PRDATA[29]|PRDATA[31]|PRDATA[9]|PSLVERR|VGND
+ sky130_fd_pr__nfet_01v8 L=0.15 W=0.42 AS=0.1346 AD=0.0441 PS=1.15 PD=0.63
M$777
+ LO|PRDATA[10]|PRDATA[12]|PRDATA[13]|PRDATA[15]|PRDATA[16]|PRDATA[17]|PRDATA[18]|PRDATA[19]|PRDATA[21]|PRDATA[23]|PRDATA[27]|PRDATA[28]|PRDATA[29]|PRDATA[31]|PRDATA[9]|PSLVERR|VGND
+ \$82 \$105
+ LO|PRDATA[10]|PRDATA[12]|PRDATA[13]|PRDATA[15]|PRDATA[16]|PRDATA[17]|PRDATA[18]|PRDATA[19]|PRDATA[21]|PRDATA[23]|PRDATA[27]|PRDATA[28]|PRDATA[29]|PRDATA[31]|PRDATA[9]|PSLVERR|VGND
+ sky130_fd_pr__nfet_01v8 L=0.15 W=0.64 AS=0.1346 AD=0.0999 PS=1.15 PD=0.985
M$778 \$105 \$80 \$84
+ LO|PRDATA[10]|PRDATA[12]|PRDATA[13]|PRDATA[15]|PRDATA[16]|PRDATA[17]|PRDATA[18]|PRDATA[19]|PRDATA[21]|PRDATA[23]|PRDATA[27]|PRDATA[28]|PRDATA[29]|PRDATA[31]|PRDATA[9]|PSLVERR|VGND
+ sky130_fd_pr__nfet_01v8 L=0.15 W=0.36 AS=0.0999 AD=0.0711 PS=0.985 PD=0.755
M$779 \$122 \$79 \$84
+ LO|PRDATA[10]|PRDATA[12]|PRDATA[13]|PRDATA[15]|PRDATA[16]|PRDATA[17]|PRDATA[18]|PRDATA[19]|PRDATA[21]|PRDATA[23]|PRDATA[27]|PRDATA[28]|PRDATA[29]|PRDATA[31]|PRDATA[9]|PSLVERR|VGND
+ sky130_fd_pr__nfet_01v8 L=0.15 W=0.36 AS=0.0669 AD=0.0711 PS=0.75 PD=0.755
M$780 \$122 \$85
+ LO|PRDATA[10]|PRDATA[12]|PRDATA[13]|PRDATA[15]|PRDATA[16]|PRDATA[17]|PRDATA[18]|PRDATA[19]|PRDATA[21]|PRDATA[23]|PRDATA[27]|PRDATA[28]|PRDATA[29]|PRDATA[31]|PRDATA[9]|PSLVERR|VGND
+ LO|PRDATA[10]|PRDATA[12]|PRDATA[13]|PRDATA[15]|PRDATA[16]|PRDATA[17]|PRDATA[18]|PRDATA[19]|PRDATA[21]|PRDATA[23]|PRDATA[27]|PRDATA[28]|PRDATA[29]|PRDATA[31]|PRDATA[9]|PSLVERR|VGND
+ sky130_fd_pr__nfet_01v8 L=0.15 W=0.42 AS=0.0669 AD=0.12495 PS=0.75 PD=1.015
M$781
+ LO|PRDATA[10]|PRDATA[12]|PRDATA[13]|PRDATA[15]|PRDATA[16]|PRDATA[17]|PRDATA[18]|PRDATA[19]|PRDATA[21]|PRDATA[23]|PRDATA[27]|PRDATA[28]|PRDATA[29]|PRDATA[31]|PRDATA[9]|PSLVERR|VGND
+ PRESETn|RESET_B \$123
+ LO|PRDATA[10]|PRDATA[12]|PRDATA[13]|PRDATA[15]|PRDATA[16]|PRDATA[17]|PRDATA[18]|PRDATA[19]|PRDATA[21]|PRDATA[23]|PRDATA[27]|PRDATA[28]|PRDATA[29]|PRDATA[31]|PRDATA[9]|PSLVERR|VGND
+ sky130_fd_pr__nfet_01v8 L=0.15 W=0.42 AS=0.12495 AD=0.06405 PS=1.015 PD=0.725
M$782 \$123 \$84 \$85
+ LO|PRDATA[10]|PRDATA[12]|PRDATA[13]|PRDATA[15]|PRDATA[16]|PRDATA[17]|PRDATA[18]|PRDATA[19]|PRDATA[21]|PRDATA[23]|PRDATA[27]|PRDATA[28]|PRDATA[29]|PRDATA[31]|PRDATA[9]|PSLVERR|VGND
+ sky130_fd_pr__nfet_01v8 L=0.15 W=0.42 AS=0.06405 AD=0.1092 PS=0.725 PD=1.36
M$783 \$118 A1|gpio_in[1]
+ LO|PRDATA[10]|PRDATA[12]|PRDATA[13]|PRDATA[15]|PRDATA[16]|PRDATA[17]|PRDATA[18]|PRDATA[19]|PRDATA[21]|PRDATA[23]|PRDATA[27]|PRDATA[28]|PRDATA[29]|PRDATA[31]|PRDATA[9]|PSLVERR|VGND
+ LO|PRDATA[10]|PRDATA[12]|PRDATA[13]|PRDATA[15]|PRDATA[16]|PRDATA[17]|PRDATA[18]|PRDATA[19]|PRDATA[21]|PRDATA[23]|PRDATA[27]|PRDATA[28]|PRDATA[29]|PRDATA[31]|PRDATA[9]|PSLVERR|VGND
+ sky130_fd_pr__nfet_01v8 L=0.15 W=0.42 AS=0.1113 AD=0.0588 PS=1.37 PD=0.7
M$784
+ LO|PRDATA[10]|PRDATA[12]|PRDATA[13]|PRDATA[15]|PRDATA[16]|PRDATA[17]|PRDATA[18]|PRDATA[19]|PRDATA[21]|PRDATA[23]|PRDATA[27]|PRDATA[28]|PRDATA[29]|PRDATA[31]|PRDATA[9]|PSLVERR|VGND
+ A|A2|C|D_N|X \$118
+ LO|PRDATA[10]|PRDATA[12]|PRDATA[13]|PRDATA[15]|PRDATA[16]|PRDATA[17]|PRDATA[18]|PRDATA[19]|PRDATA[21]|PRDATA[23]|PRDATA[27]|PRDATA[28]|PRDATA[29]|PRDATA[31]|PRDATA[9]|PSLVERR|VGND
+ sky130_fd_pr__nfet_01v8 L=0.15 W=0.42 AS=0.0588 AD=0.0588 PS=0.7 PD=0.7
M$785 \$118 B|B1|Y A1|Y
+ LO|PRDATA[10]|PRDATA[12]|PRDATA[13]|PRDATA[15]|PRDATA[16]|PRDATA[17]|PRDATA[18]|PRDATA[19]|PRDATA[21]|PRDATA[23]|PRDATA[27]|PRDATA[28]|PRDATA[29]|PRDATA[31]|PRDATA[9]|PSLVERR|VGND
+ sky130_fd_pr__nfet_01v8 L=0.15 W=0.42 AS=0.0588 AD=0.1113 PS=0.7 PD=1.37
M$786 \$94 CLK|X
+ LO|PRDATA[10]|PRDATA[12]|PRDATA[13]|PRDATA[15]|PRDATA[16]|PRDATA[17]|PRDATA[18]|PRDATA[19]|PRDATA[21]|PRDATA[23]|PRDATA[27]|PRDATA[28]|PRDATA[29]|PRDATA[31]|PRDATA[9]|PSLVERR|VGND
+ LO|PRDATA[10]|PRDATA[12]|PRDATA[13]|PRDATA[15]|PRDATA[16]|PRDATA[17]|PRDATA[18]|PRDATA[19]|PRDATA[21]|PRDATA[23]|PRDATA[27]|PRDATA[28]|PRDATA[29]|PRDATA[31]|PRDATA[9]|PSLVERR|VGND
+ sky130_fd_pr__nfet_01v8 L=0.15 W=0.42 AS=0.1092 AD=0.0567 PS=1.36 PD=0.69
M$787
+ LO|PRDATA[10]|PRDATA[12]|PRDATA[13]|PRDATA[15]|PRDATA[16]|PRDATA[17]|PRDATA[18]|PRDATA[19]|PRDATA[21]|PRDATA[23]|PRDATA[27]|PRDATA[28]|PRDATA[29]|PRDATA[31]|PRDATA[9]|PSLVERR|VGND
+ \$94 \$95
+ LO|PRDATA[10]|PRDATA[12]|PRDATA[13]|PRDATA[15]|PRDATA[16]|PRDATA[17]|PRDATA[18]|PRDATA[19]|PRDATA[21]|PRDATA[23]|PRDATA[27]|PRDATA[28]|PRDATA[29]|PRDATA[31]|PRDATA[9]|PSLVERR|VGND
+ sky130_fd_pr__nfet_01v8 L=0.15 W=0.42 AS=0.0567 AD=0.1092 PS=0.69 PD=1.36
M$788
+ LO|PRDATA[10]|PRDATA[12]|PRDATA[13]|PRDATA[15]|PRDATA[16]|PRDATA[17]|PRDATA[18]|PRDATA[19]|PRDATA[21]|PRDATA[23]|PRDATA[27]|PRDATA[28]|PRDATA[29]|PRDATA[31]|PRDATA[9]|PSLVERR|VGND
+ D|X \$96
+ LO|PRDATA[10]|PRDATA[12]|PRDATA[13]|PRDATA[15]|PRDATA[16]|PRDATA[17]|PRDATA[18]|PRDATA[19]|PRDATA[21]|PRDATA[23]|PRDATA[27]|PRDATA[28]|PRDATA[29]|PRDATA[31]|PRDATA[9]|PSLVERR|VGND
+ sky130_fd_pr__nfet_01v8 L=0.15 W=0.42 AS=0.2205 AD=0.066 PS=1.89 PD=0.745
M$789 \$96 \$94 \$97
+ LO|PRDATA[10]|PRDATA[12]|PRDATA[13]|PRDATA[15]|PRDATA[16]|PRDATA[17]|PRDATA[18]|PRDATA[19]|PRDATA[21]|PRDATA[23]|PRDATA[27]|PRDATA[28]|PRDATA[29]|PRDATA[31]|PRDATA[9]|PSLVERR|VGND
+ sky130_fd_pr__nfet_01v8 L=0.15 W=0.36 AS=0.066 AD=0.0594 PS=0.745 PD=0.69
M$790 \$127 \$95 \$97
+ LO|PRDATA[10]|PRDATA[12]|PRDATA[13]|PRDATA[15]|PRDATA[16]|PRDATA[17]|PRDATA[18]|PRDATA[19]|PRDATA[21]|PRDATA[23]|PRDATA[27]|PRDATA[28]|PRDATA[29]|PRDATA[31]|PRDATA[9]|PSLVERR|VGND
+ sky130_fd_pr__nfet_01v8 L=0.15 W=0.36 AS=0.1401 AD=0.0594 PS=1.1 PD=0.69
M$791 \$127 \$113 \$126
+ LO|PRDATA[10]|PRDATA[12]|PRDATA[13]|PRDATA[15]|PRDATA[16]|PRDATA[17]|PRDATA[18]|PRDATA[19]|PRDATA[21]|PRDATA[23]|PRDATA[27]|PRDATA[28]|PRDATA[29]|PRDATA[31]|PRDATA[9]|PSLVERR|VGND
+ sky130_fd_pr__nfet_01v8 L=0.15 W=0.42 AS=0.1401 AD=0.0441 PS=1.1 PD=0.63
M$792
+ LO|PRDATA[10]|PRDATA[12]|PRDATA[13]|PRDATA[15]|PRDATA[16]|PRDATA[17]|PRDATA[18]|PRDATA[19]|PRDATA[21]|PRDATA[23]|PRDATA[27]|PRDATA[28]|PRDATA[29]|PRDATA[31]|PRDATA[9]|PSLVERR|VGND
+ PRESETn|RESET_B \$126
+ LO|PRDATA[10]|PRDATA[12]|PRDATA[13]|PRDATA[15]|PRDATA[16]|PRDATA[17]|PRDATA[18]|PRDATA[19]|PRDATA[21]|PRDATA[23]|PRDATA[27]|PRDATA[28]|PRDATA[29]|PRDATA[31]|PRDATA[9]|PSLVERR|VGND
+ sky130_fd_pr__nfet_01v8 L=0.15 W=0.42 AS=0.1346 AD=0.0441 PS=1.15 PD=0.63
M$793
+ LO|PRDATA[10]|PRDATA[12]|PRDATA[13]|PRDATA[15]|PRDATA[16]|PRDATA[17]|PRDATA[18]|PRDATA[19]|PRDATA[21]|PRDATA[23]|PRDATA[27]|PRDATA[28]|PRDATA[29]|PRDATA[31]|PRDATA[9]|PSLVERR|VGND
+ \$97 \$113
+ LO|PRDATA[10]|PRDATA[12]|PRDATA[13]|PRDATA[15]|PRDATA[16]|PRDATA[17]|PRDATA[18]|PRDATA[19]|PRDATA[21]|PRDATA[23]|PRDATA[27]|PRDATA[28]|PRDATA[29]|PRDATA[31]|PRDATA[9]|PSLVERR|VGND
+ sky130_fd_pr__nfet_01v8 L=0.15 W=0.64 AS=0.1346 AD=0.0999 PS=1.15 PD=0.985
M$794 \$113 \$95 \$99
+ LO|PRDATA[10]|PRDATA[12]|PRDATA[13]|PRDATA[15]|PRDATA[16]|PRDATA[17]|PRDATA[18]|PRDATA[19]|PRDATA[21]|PRDATA[23]|PRDATA[27]|PRDATA[28]|PRDATA[29]|PRDATA[31]|PRDATA[9]|PSLVERR|VGND
+ sky130_fd_pr__nfet_01v8 L=0.15 W=0.36 AS=0.0999 AD=0.0711 PS=0.985 PD=0.755
M$795 \$124 \$94 \$99
+ LO|PRDATA[10]|PRDATA[12]|PRDATA[13]|PRDATA[15]|PRDATA[16]|PRDATA[17]|PRDATA[18]|PRDATA[19]|PRDATA[21]|PRDATA[23]|PRDATA[27]|PRDATA[28]|PRDATA[29]|PRDATA[31]|PRDATA[9]|PSLVERR|VGND
+ sky130_fd_pr__nfet_01v8 L=0.15 W=0.36 AS=0.0669 AD=0.0711 PS=0.75 PD=0.755
M$796 \$124 \$100
+ LO|PRDATA[10]|PRDATA[12]|PRDATA[13]|PRDATA[15]|PRDATA[16]|PRDATA[17]|PRDATA[18]|PRDATA[19]|PRDATA[21]|PRDATA[23]|PRDATA[27]|PRDATA[28]|PRDATA[29]|PRDATA[31]|PRDATA[9]|PSLVERR|VGND
+ LO|PRDATA[10]|PRDATA[12]|PRDATA[13]|PRDATA[15]|PRDATA[16]|PRDATA[17]|PRDATA[18]|PRDATA[19]|PRDATA[21]|PRDATA[23]|PRDATA[27]|PRDATA[28]|PRDATA[29]|PRDATA[31]|PRDATA[9]|PSLVERR|VGND
+ sky130_fd_pr__nfet_01v8 L=0.15 W=0.42 AS=0.0669 AD=0.12495 PS=0.75 PD=1.015
M$797
+ LO|PRDATA[10]|PRDATA[12]|PRDATA[13]|PRDATA[15]|PRDATA[16]|PRDATA[17]|PRDATA[18]|PRDATA[19]|PRDATA[21]|PRDATA[23]|PRDATA[27]|PRDATA[28]|PRDATA[29]|PRDATA[31]|PRDATA[9]|PSLVERR|VGND
+ PRESETn|RESET_B \$121
+ LO|PRDATA[10]|PRDATA[12]|PRDATA[13]|PRDATA[15]|PRDATA[16]|PRDATA[17]|PRDATA[18]|PRDATA[19]|PRDATA[21]|PRDATA[23]|PRDATA[27]|PRDATA[28]|PRDATA[29]|PRDATA[31]|PRDATA[9]|PSLVERR|VGND
+ sky130_fd_pr__nfet_01v8 L=0.15 W=0.42 AS=0.12495 AD=0.06405 PS=1.015 PD=0.725
M$798 \$121 \$99 \$100
+ LO|PRDATA[10]|PRDATA[12]|PRDATA[13]|PRDATA[15]|PRDATA[16]|PRDATA[17]|PRDATA[18]|PRDATA[19]|PRDATA[21]|PRDATA[23]|PRDATA[27]|PRDATA[28]|PRDATA[29]|PRDATA[31]|PRDATA[9]|PSLVERR|VGND
+ sky130_fd_pr__nfet_01v8 L=0.15 W=0.42 AS=0.06405 AD=0.1092 PS=0.725 PD=1.36
M$799 \$134 CLK|X
+ LO|PRDATA[10]|PRDATA[12]|PRDATA[13]|PRDATA[15]|PRDATA[16]|PRDATA[17]|PRDATA[18]|PRDATA[19]|PRDATA[21]|PRDATA[23]|PRDATA[27]|PRDATA[28]|PRDATA[29]|PRDATA[31]|PRDATA[9]|PSLVERR|VGND
+ LO|PRDATA[10]|PRDATA[12]|PRDATA[13]|PRDATA[15]|PRDATA[16]|PRDATA[17]|PRDATA[18]|PRDATA[19]|PRDATA[21]|PRDATA[23]|PRDATA[27]|PRDATA[28]|PRDATA[29]|PRDATA[31]|PRDATA[9]|PSLVERR|VGND
+ sky130_fd_pr__nfet_01v8 L=0.15 W=0.42 AS=0.1092 AD=0.0567 PS=1.36 PD=0.69
M$800
+ LO|PRDATA[10]|PRDATA[12]|PRDATA[13]|PRDATA[15]|PRDATA[16]|PRDATA[17]|PRDATA[18]|PRDATA[19]|PRDATA[21]|PRDATA[23]|PRDATA[27]|PRDATA[28]|PRDATA[29]|PRDATA[31]|PRDATA[9]|PSLVERR|VGND
+ \$134 \$135
+ LO|PRDATA[10]|PRDATA[12]|PRDATA[13]|PRDATA[15]|PRDATA[16]|PRDATA[17]|PRDATA[18]|PRDATA[19]|PRDATA[21]|PRDATA[23]|PRDATA[27]|PRDATA[28]|PRDATA[29]|PRDATA[31]|PRDATA[9]|PSLVERR|VGND
+ sky130_fd_pr__nfet_01v8 L=0.15 W=0.42 AS=0.0567 AD=0.1092 PS=0.69 PD=1.36
M$801 \$136 \$134 \$137
+ LO|PRDATA[10]|PRDATA[12]|PRDATA[13]|PRDATA[15]|PRDATA[16]|PRDATA[17]|PRDATA[18]|PRDATA[19]|PRDATA[21]|PRDATA[23]|PRDATA[27]|PRDATA[28]|PRDATA[29]|PRDATA[31]|PRDATA[9]|PSLVERR|VGND
+ sky130_fd_pr__nfet_01v8 L=0.15 W=0.36 AS=0.066 AD=0.0594 PS=0.745 PD=0.69
M$802 \$137 \$135 \$163
+ LO|PRDATA[10]|PRDATA[12]|PRDATA[13]|PRDATA[15]|PRDATA[16]|PRDATA[17]|PRDATA[18]|PRDATA[19]|PRDATA[21]|PRDATA[23]|PRDATA[27]|PRDATA[28]|PRDATA[29]|PRDATA[31]|PRDATA[9]|PSLVERR|VGND
+ sky130_fd_pr__nfet_01v8 L=0.15 W=0.36 AS=0.0594 AD=0.1401 PS=0.69 PD=1.1
M$803 \$209 \$135 \$138
+ LO|PRDATA[10]|PRDATA[12]|PRDATA[13]|PRDATA[15]|PRDATA[16]|PRDATA[17]|PRDATA[18]|PRDATA[19]|PRDATA[21]|PRDATA[23]|PRDATA[27]|PRDATA[28]|PRDATA[29]|PRDATA[31]|PRDATA[9]|PSLVERR|VGND
+ sky130_fd_pr__nfet_01v8 L=0.15 W=0.36 AS=0.0999 AD=0.0711 PS=0.985 PD=0.755
M$804 \$138 \$134 \$166
+ LO|PRDATA[10]|PRDATA[12]|PRDATA[13]|PRDATA[15]|PRDATA[16]|PRDATA[17]|PRDATA[18]|PRDATA[19]|PRDATA[21]|PRDATA[23]|PRDATA[27]|PRDATA[28]|PRDATA[29]|PRDATA[31]|PRDATA[9]|PSLVERR|VGND
+ sky130_fd_pr__nfet_01v8 L=0.15 W=0.36 AS=0.0711 AD=0.0669 PS=0.755 PD=0.75
M$805
+ LO|PRDATA[10]|PRDATA[12]|PRDATA[13]|PRDATA[15]|PRDATA[16]|PRDATA[17]|PRDATA[18]|PRDATA[19]|PRDATA[21]|PRDATA[23]|PRDATA[27]|PRDATA[28]|PRDATA[29]|PRDATA[31]|PRDATA[9]|PSLVERR|VGND
+ D|X \$136
+ LO|PRDATA[10]|PRDATA[12]|PRDATA[13]|PRDATA[15]|PRDATA[16]|PRDATA[17]|PRDATA[18]|PRDATA[19]|PRDATA[21]|PRDATA[23]|PRDATA[27]|PRDATA[28]|PRDATA[29]|PRDATA[31]|PRDATA[9]|PSLVERR|VGND
+ sky130_fd_pr__nfet_01v8 L=0.15 W=0.42 AS=0.2205 AD=0.066 PS=1.89 PD=0.745
M$806 \$163 \$209 \$165
+ LO|PRDATA[10]|PRDATA[12]|PRDATA[13]|PRDATA[15]|PRDATA[16]|PRDATA[17]|PRDATA[18]|PRDATA[19]|PRDATA[21]|PRDATA[23]|PRDATA[27]|PRDATA[28]|PRDATA[29]|PRDATA[31]|PRDATA[9]|PSLVERR|VGND
+ sky130_fd_pr__nfet_01v8 L=0.15 W=0.42 AS=0.1401 AD=0.0441 PS=1.1 PD=0.63
M$807 \$165 PRESETn|RESET_B
+ LO|PRDATA[10]|PRDATA[12]|PRDATA[13]|PRDATA[15]|PRDATA[16]|PRDATA[17]|PRDATA[18]|PRDATA[19]|PRDATA[21]|PRDATA[23]|PRDATA[27]|PRDATA[28]|PRDATA[29]|PRDATA[31]|PRDATA[9]|PSLVERR|VGND
+ LO|PRDATA[10]|PRDATA[12]|PRDATA[13]|PRDATA[15]|PRDATA[16]|PRDATA[17]|PRDATA[18]|PRDATA[19]|PRDATA[21]|PRDATA[23]|PRDATA[27]|PRDATA[28]|PRDATA[29]|PRDATA[31]|PRDATA[9]|PSLVERR|VGND
+ sky130_fd_pr__nfet_01v8 L=0.15 W=0.42 AS=0.0441 AD=0.1346 PS=0.63 PD=1.15
M$808 \$166 \$139
+ LO|PRDATA[10]|PRDATA[12]|PRDATA[13]|PRDATA[15]|PRDATA[16]|PRDATA[17]|PRDATA[18]|PRDATA[19]|PRDATA[21]|PRDATA[23]|PRDATA[27]|PRDATA[28]|PRDATA[29]|PRDATA[31]|PRDATA[9]|PSLVERR|VGND
+ LO|PRDATA[10]|PRDATA[12]|PRDATA[13]|PRDATA[15]|PRDATA[16]|PRDATA[17]|PRDATA[18]|PRDATA[19]|PRDATA[21]|PRDATA[23]|PRDATA[27]|PRDATA[28]|PRDATA[29]|PRDATA[31]|PRDATA[9]|PSLVERR|VGND
+ sky130_fd_pr__nfet_01v8 L=0.15 W=0.42 AS=0.0669 AD=0.12495 PS=0.75 PD=1.015
M$809
+ LO|PRDATA[10]|PRDATA[12]|PRDATA[13]|PRDATA[15]|PRDATA[16]|PRDATA[17]|PRDATA[18]|PRDATA[19]|PRDATA[21]|PRDATA[23]|PRDATA[27]|PRDATA[28]|PRDATA[29]|PRDATA[31]|PRDATA[9]|PSLVERR|VGND
+ PRESETn|RESET_B \$168
+ LO|PRDATA[10]|PRDATA[12]|PRDATA[13]|PRDATA[15]|PRDATA[16]|PRDATA[17]|PRDATA[18]|PRDATA[19]|PRDATA[21]|PRDATA[23]|PRDATA[27]|PRDATA[28]|PRDATA[29]|PRDATA[31]|PRDATA[9]|PSLVERR|VGND
+ sky130_fd_pr__nfet_01v8 L=0.15 W=0.42 AS=0.12495 AD=0.06405 PS=1.015 PD=0.725
M$810 \$168 \$138 \$139
+ LO|PRDATA[10]|PRDATA[12]|PRDATA[13]|PRDATA[15]|PRDATA[16]|PRDATA[17]|PRDATA[18]|PRDATA[19]|PRDATA[21]|PRDATA[23]|PRDATA[27]|PRDATA[28]|PRDATA[29]|PRDATA[31]|PRDATA[9]|PSLVERR|VGND
+ sky130_fd_pr__nfet_01v8 L=0.15 W=0.42 AS=0.06405 AD=0.1092 PS=0.725 PD=1.36
M$811
+ LO|PRDATA[10]|PRDATA[12]|PRDATA[13]|PRDATA[15]|PRDATA[16]|PRDATA[17]|PRDATA[18]|PRDATA[19]|PRDATA[21]|PRDATA[23]|PRDATA[27]|PRDATA[28]|PRDATA[29]|PRDATA[31]|PRDATA[9]|PSLVERR|VGND
+ \$137 \$209
+ LO|PRDATA[10]|PRDATA[12]|PRDATA[13]|PRDATA[15]|PRDATA[16]|PRDATA[17]|PRDATA[18]|PRDATA[19]|PRDATA[21]|PRDATA[23]|PRDATA[27]|PRDATA[28]|PRDATA[29]|PRDATA[31]|PRDATA[9]|PSLVERR|VGND
+ sky130_fd_pr__nfet_01v8 L=0.15 W=0.64 AS=0.1346 AD=0.0999 PS=1.15 PD=0.985
M$812
+ LO|PRDATA[10]|PRDATA[12]|PRDATA[13]|PRDATA[15]|PRDATA[16]|PRDATA[17]|PRDATA[18]|PRDATA[19]|PRDATA[21]|PRDATA[23]|PRDATA[27]|PRDATA[28]|PRDATA[29]|PRDATA[31]|PRDATA[9]|PSLVERR|VGND
+ \$139 A0|A1|Q|gpio_out[0]
+ LO|PRDATA[10]|PRDATA[12]|PRDATA[13]|PRDATA[15]|PRDATA[16]|PRDATA[17]|PRDATA[18]|PRDATA[19]|PRDATA[21]|PRDATA[23]|PRDATA[27]|PRDATA[28]|PRDATA[29]|PRDATA[31]|PRDATA[9]|PSLVERR|VGND
+ sky130_fd_pr__nfet_01v8 L=0.15 W=0.65 AS=0.2087 AD=0.169 PS=2.02 PD=1.82
M$813
+ LO|PRDATA[10]|PRDATA[12]|PRDATA[13]|PRDATA[15]|PRDATA[16]|PRDATA[17]|PRDATA[18]|PRDATA[19]|PRDATA[21]|PRDATA[23]|PRDATA[27]|PRDATA[28]|PRDATA[29]|PRDATA[31]|PRDATA[9]|PSLVERR|VGND
+ A0|B2|Q|gpio_oe[0] \$206
+ LO|PRDATA[10]|PRDATA[12]|PRDATA[13]|PRDATA[15]|PRDATA[16]|PRDATA[17]|PRDATA[18]|PRDATA[19]|PRDATA[21]|PRDATA[23]|PRDATA[27]|PRDATA[28]|PRDATA[29]|PRDATA[31]|PRDATA[9]|PSLVERR|VGND
+ sky130_fd_pr__nfet_01v8 L=0.15 W=0.65 AS=0.169 AD=0.07475 PS=1.82 PD=0.88
M$814 \$206 B|B1|B_N|Y A2|Y
+ LO|PRDATA[10]|PRDATA[12]|PRDATA[13]|PRDATA[15]|PRDATA[16]|PRDATA[17]|PRDATA[18]|PRDATA[19]|PRDATA[21]|PRDATA[23]|PRDATA[27]|PRDATA[28]|PRDATA[29]|PRDATA[31]|PRDATA[9]|PSLVERR|VGND
+ sky130_fd_pr__nfet_01v8 L=0.15 W=0.65 AS=0.07475 AD=0.169 PS=0.88 PD=1.82
M$815 A2|Y A0|A1|Q|gpio_out[0] \$207
+ LO|PRDATA[10]|PRDATA[12]|PRDATA[13]|PRDATA[15]|PRDATA[16]|PRDATA[17]|PRDATA[18]|PRDATA[19]|PRDATA[21]|PRDATA[23]|PRDATA[27]|PRDATA[28]|PRDATA[29]|PRDATA[31]|PRDATA[9]|PSLVERR|VGND
+ sky130_fd_pr__nfet_01v8 L=0.15 W=0.65 AS=0.169 AD=0.06825 PS=1.82 PD=0.86
M$816 \$207 A2|B|C2|Y
+ LO|PRDATA[10]|PRDATA[12]|PRDATA[13]|PRDATA[15]|PRDATA[16]|PRDATA[17]|PRDATA[18]|PRDATA[19]|PRDATA[21]|PRDATA[23]|PRDATA[27]|PRDATA[28]|PRDATA[29]|PRDATA[31]|PRDATA[9]|PSLVERR|VGND
+ LO|PRDATA[10]|PRDATA[12]|PRDATA[13]|PRDATA[15]|PRDATA[16]|PRDATA[17]|PRDATA[18]|PRDATA[19]|PRDATA[21]|PRDATA[23]|PRDATA[27]|PRDATA[28]|PRDATA[29]|PRDATA[31]|PRDATA[9]|PSLVERR|VGND
+ sky130_fd_pr__nfet_01v8 L=0.15 W=0.65 AS=0.06825 AD=0.234 PS=0.86 PD=2.02
M$817 \$141 A1|gpio_in[0]
+ LO|PRDATA[10]|PRDATA[12]|PRDATA[13]|PRDATA[15]|PRDATA[16]|PRDATA[17]|PRDATA[18]|PRDATA[19]|PRDATA[21]|PRDATA[23]|PRDATA[27]|PRDATA[28]|PRDATA[29]|PRDATA[31]|PRDATA[9]|PSLVERR|VGND
+ LO|PRDATA[10]|PRDATA[12]|PRDATA[13]|PRDATA[15]|PRDATA[16]|PRDATA[17]|PRDATA[18]|PRDATA[19]|PRDATA[21]|PRDATA[23]|PRDATA[27]|PRDATA[28]|PRDATA[29]|PRDATA[31]|PRDATA[9]|PSLVERR|VGND
+ sky130_fd_pr__nfet_01v8 L=0.15 W=0.42 AS=0.1113 AD=0.0588 PS=1.37 PD=0.7
M$818
+ LO|PRDATA[10]|PRDATA[12]|PRDATA[13]|PRDATA[15]|PRDATA[16]|PRDATA[17]|PRDATA[18]|PRDATA[19]|PRDATA[21]|PRDATA[23]|PRDATA[27]|PRDATA[28]|PRDATA[29]|PRDATA[31]|PRDATA[9]|PSLVERR|VGND
+ A|A2|C|D_N|X \$141
+ LO|PRDATA[10]|PRDATA[12]|PRDATA[13]|PRDATA[15]|PRDATA[16]|PRDATA[17]|PRDATA[18]|PRDATA[19]|PRDATA[21]|PRDATA[23]|PRDATA[27]|PRDATA[28]|PRDATA[29]|PRDATA[31]|PRDATA[9]|PSLVERR|VGND
+ sky130_fd_pr__nfet_01v8 L=0.15 W=0.42 AS=0.0588 AD=0.0588 PS=0.7 PD=0.7
M$819 \$141 B|B1|Y A1|Y
+ LO|PRDATA[10]|PRDATA[12]|PRDATA[13]|PRDATA[15]|PRDATA[16]|PRDATA[17]|PRDATA[18]|PRDATA[19]|PRDATA[21]|PRDATA[23]|PRDATA[27]|PRDATA[28]|PRDATA[29]|PRDATA[31]|PRDATA[9]|PSLVERR|VGND
+ sky130_fd_pr__nfet_01v8 L=0.15 W=0.42 AS=0.0588 AD=0.1113 PS=0.7 PD=1.37
M$820
+ LO|PRDATA[10]|PRDATA[12]|PRDATA[13]|PRDATA[15]|PRDATA[16]|PRDATA[17]|PRDATA[18]|PRDATA[19]|PRDATA[21]|PRDATA[23]|PRDATA[27]|PRDATA[28]|PRDATA[29]|PRDATA[31]|PRDATA[9]|PSLVERR|VGND
+ S|X \$185
+ LO|PRDATA[10]|PRDATA[12]|PRDATA[13]|PRDATA[15]|PRDATA[16]|PRDATA[17]|PRDATA[18]|PRDATA[19]|PRDATA[21]|PRDATA[23]|PRDATA[27]|PRDATA[28]|PRDATA[29]|PRDATA[31]|PRDATA[9]|PSLVERR|VGND
+ sky130_fd_pr__nfet_01v8 L=0.15 W=0.42 AS=0.11285 AD=0.0693 PS=1.045 PD=0.75
M$821 \$185 A1|PWDATA[1] \$142
+ LO|PRDATA[10]|PRDATA[12]|PRDATA[13]|PRDATA[15]|PRDATA[16]|PRDATA[17]|PRDATA[18]|PRDATA[19]|PRDATA[21]|PRDATA[23]|PRDATA[27]|PRDATA[28]|PRDATA[29]|PRDATA[31]|PRDATA[9]|PSLVERR|VGND
+ sky130_fd_pr__nfet_01v8 L=0.15 W=0.42 AS=0.0693 AD=0.09975 PS=0.75 PD=0.895
M$822 \$142 A0|B2|Q|gpio_oe[1] \$187
+ LO|PRDATA[10]|PRDATA[12]|PRDATA[13]|PRDATA[15]|PRDATA[16]|PRDATA[17]|PRDATA[18]|PRDATA[19]|PRDATA[21]|PRDATA[23]|PRDATA[27]|PRDATA[28]|PRDATA[29]|PRDATA[31]|PRDATA[9]|PSLVERR|VGND
+ sky130_fd_pr__nfet_01v8 L=0.15 W=0.42 AS=0.09975 AD=0.0693 PS=0.895 PD=0.75
M$823 \$187 \$144
+ LO|PRDATA[10]|PRDATA[12]|PRDATA[13]|PRDATA[15]|PRDATA[16]|PRDATA[17]|PRDATA[18]|PRDATA[19]|PRDATA[21]|PRDATA[23]|PRDATA[27]|PRDATA[28]|PRDATA[29]|PRDATA[31]|PRDATA[9]|PSLVERR|VGND
+ LO|PRDATA[10]|PRDATA[12]|PRDATA[13]|PRDATA[15]|PRDATA[16]|PRDATA[17]|PRDATA[18]|PRDATA[19]|PRDATA[21]|PRDATA[23]|PRDATA[27]|PRDATA[28]|PRDATA[29]|PRDATA[31]|PRDATA[9]|PSLVERR|VGND
+ sky130_fd_pr__nfet_01v8 L=0.15 W=0.42 AS=0.0693 AD=0.1449 PS=0.75 PD=1.11
M$824
+ LO|PRDATA[10]|PRDATA[12]|PRDATA[13]|PRDATA[15]|PRDATA[16]|PRDATA[17]|PRDATA[18]|PRDATA[19]|PRDATA[21]|PRDATA[23]|PRDATA[27]|PRDATA[28]|PRDATA[29]|PRDATA[31]|PRDATA[9]|PSLVERR|VGND
+ S|X \$144
+ LO|PRDATA[10]|PRDATA[12]|PRDATA[13]|PRDATA[15]|PRDATA[16]|PRDATA[17]|PRDATA[18]|PRDATA[19]|PRDATA[21]|PRDATA[23]|PRDATA[27]|PRDATA[28]|PRDATA[29]|PRDATA[31]|PRDATA[9]|PSLVERR|VGND
+ sky130_fd_pr__nfet_01v8 L=0.15 W=0.42 AS=0.1449 AD=0.1092 PS=1.11 PD=1.36
M$825 A|X \$142
+ LO|PRDATA[10]|PRDATA[12]|PRDATA[13]|PRDATA[15]|PRDATA[16]|PRDATA[17]|PRDATA[18]|PRDATA[19]|PRDATA[21]|PRDATA[23]|PRDATA[27]|PRDATA[28]|PRDATA[29]|PRDATA[31]|PRDATA[9]|PSLVERR|VGND
+ LO|PRDATA[10]|PRDATA[12]|PRDATA[13]|PRDATA[15]|PRDATA[16]|PRDATA[17]|PRDATA[18]|PRDATA[19]|PRDATA[21]|PRDATA[23]|PRDATA[27]|PRDATA[28]|PRDATA[29]|PRDATA[31]|PRDATA[9]|PSLVERR|VGND
+ sky130_fd_pr__nfet_01v8 L=0.15 W=0.65 AS=0.169 AD=0.11285 PS=1.82 PD=1.045
M$826
+ LO|PRDATA[10]|PRDATA[12]|PRDATA[13]|PRDATA[15]|PRDATA[16]|PRDATA[17]|PRDATA[18]|PRDATA[19]|PRDATA[21]|PRDATA[23]|PRDATA[27]|PRDATA[28]|PRDATA[29]|PRDATA[31]|PRDATA[9]|PSLVERR|VGND
+ A0|B2|Q|gpio_oe[1] \$204
+ LO|PRDATA[10]|PRDATA[12]|PRDATA[13]|PRDATA[15]|PRDATA[16]|PRDATA[17]|PRDATA[18]|PRDATA[19]|PRDATA[21]|PRDATA[23]|PRDATA[27]|PRDATA[28]|PRDATA[29]|PRDATA[31]|PRDATA[9]|PSLVERR|VGND
+ sky130_fd_pr__nfet_01v8 L=0.15 W=0.65 AS=0.169 AD=0.07475 PS=1.82 PD=0.88
M$827 \$204 B|B1|B_N|Y A2|Y
+ LO|PRDATA[10]|PRDATA[12]|PRDATA[13]|PRDATA[15]|PRDATA[16]|PRDATA[17]|PRDATA[18]|PRDATA[19]|PRDATA[21]|PRDATA[23]|PRDATA[27]|PRDATA[28]|PRDATA[29]|PRDATA[31]|PRDATA[9]|PSLVERR|VGND
+ sky130_fd_pr__nfet_01v8 L=0.15 W=0.65 AS=0.07475 AD=0.169 PS=0.88 PD=1.82
M$828 A2|Y A0|A1|Q|gpio_out[1] \$203
+ LO|PRDATA[10]|PRDATA[12]|PRDATA[13]|PRDATA[15]|PRDATA[16]|PRDATA[17]|PRDATA[18]|PRDATA[19]|PRDATA[21]|PRDATA[23]|PRDATA[27]|PRDATA[28]|PRDATA[29]|PRDATA[31]|PRDATA[9]|PSLVERR|VGND
+ sky130_fd_pr__nfet_01v8 L=0.15 W=0.65 AS=0.169 AD=0.06825 PS=1.82 PD=0.86
M$829 \$203 A2|B|C2|Y
+ LO|PRDATA[10]|PRDATA[12]|PRDATA[13]|PRDATA[15]|PRDATA[16]|PRDATA[17]|PRDATA[18]|PRDATA[19]|PRDATA[21]|PRDATA[23]|PRDATA[27]|PRDATA[28]|PRDATA[29]|PRDATA[31]|PRDATA[9]|PSLVERR|VGND
+ LO|PRDATA[10]|PRDATA[12]|PRDATA[13]|PRDATA[15]|PRDATA[16]|PRDATA[17]|PRDATA[18]|PRDATA[19]|PRDATA[21]|PRDATA[23]|PRDATA[27]|PRDATA[28]|PRDATA[29]|PRDATA[31]|PRDATA[9]|PSLVERR|VGND
+ sky130_fd_pr__nfet_01v8 L=0.15 W=0.65 AS=0.06825 AD=0.234 PS=0.86 PD=2.02
M$830 \$146 CLK|X
+ LO|PRDATA[10]|PRDATA[12]|PRDATA[13]|PRDATA[15]|PRDATA[16]|PRDATA[17]|PRDATA[18]|PRDATA[19]|PRDATA[21]|PRDATA[23]|PRDATA[27]|PRDATA[28]|PRDATA[29]|PRDATA[31]|PRDATA[9]|PSLVERR|VGND
+ LO|PRDATA[10]|PRDATA[12]|PRDATA[13]|PRDATA[15]|PRDATA[16]|PRDATA[17]|PRDATA[18]|PRDATA[19]|PRDATA[21]|PRDATA[23]|PRDATA[27]|PRDATA[28]|PRDATA[29]|PRDATA[31]|PRDATA[9]|PSLVERR|VGND
+ sky130_fd_pr__nfet_01v8 L=0.15 W=0.42 AS=0.1092 AD=0.0567 PS=1.36 PD=0.69
M$831
+ LO|PRDATA[10]|PRDATA[12]|PRDATA[13]|PRDATA[15]|PRDATA[16]|PRDATA[17]|PRDATA[18]|PRDATA[19]|PRDATA[21]|PRDATA[23]|PRDATA[27]|PRDATA[28]|PRDATA[29]|PRDATA[31]|PRDATA[9]|PSLVERR|VGND
+ \$146 \$147
+ LO|PRDATA[10]|PRDATA[12]|PRDATA[13]|PRDATA[15]|PRDATA[16]|PRDATA[17]|PRDATA[18]|PRDATA[19]|PRDATA[21]|PRDATA[23]|PRDATA[27]|PRDATA[28]|PRDATA[29]|PRDATA[31]|PRDATA[9]|PSLVERR|VGND
+ sky130_fd_pr__nfet_01v8 L=0.15 W=0.42 AS=0.0567 AD=0.1092 PS=0.69 PD=1.36
M$832 \$148 \$146 \$149
+ LO|PRDATA[10]|PRDATA[12]|PRDATA[13]|PRDATA[15]|PRDATA[16]|PRDATA[17]|PRDATA[18]|PRDATA[19]|PRDATA[21]|PRDATA[23]|PRDATA[27]|PRDATA[28]|PRDATA[29]|PRDATA[31]|PRDATA[9]|PSLVERR|VGND
+ sky130_fd_pr__nfet_01v8 L=0.15 W=0.36 AS=0.066 AD=0.0594 PS=0.745 PD=0.69
M$833 \$149 \$147 \$199
+ LO|PRDATA[10]|PRDATA[12]|PRDATA[13]|PRDATA[15]|PRDATA[16]|PRDATA[17]|PRDATA[18]|PRDATA[19]|PRDATA[21]|PRDATA[23]|PRDATA[27]|PRDATA[28]|PRDATA[29]|PRDATA[31]|PRDATA[9]|PSLVERR|VGND
+ sky130_fd_pr__nfet_01v8 L=0.15 W=0.36 AS=0.0594 AD=0.1401 PS=0.69 PD=1.1
M$834 \$210 \$147 \$150
+ LO|PRDATA[10]|PRDATA[12]|PRDATA[13]|PRDATA[15]|PRDATA[16]|PRDATA[17]|PRDATA[18]|PRDATA[19]|PRDATA[21]|PRDATA[23]|PRDATA[27]|PRDATA[28]|PRDATA[29]|PRDATA[31]|PRDATA[9]|PSLVERR|VGND
+ sky130_fd_pr__nfet_01v8 L=0.15 W=0.36 AS=0.0999 AD=0.0711 PS=0.985 PD=0.755
M$835 \$150 \$146 \$197
+ LO|PRDATA[10]|PRDATA[12]|PRDATA[13]|PRDATA[15]|PRDATA[16]|PRDATA[17]|PRDATA[18]|PRDATA[19]|PRDATA[21]|PRDATA[23]|PRDATA[27]|PRDATA[28]|PRDATA[29]|PRDATA[31]|PRDATA[9]|PSLVERR|VGND
+ sky130_fd_pr__nfet_01v8 L=0.15 W=0.36 AS=0.0711 AD=0.0669 PS=0.755 PD=0.75
M$836
+ LO|PRDATA[10]|PRDATA[12]|PRDATA[13]|PRDATA[15]|PRDATA[16]|PRDATA[17]|PRDATA[18]|PRDATA[19]|PRDATA[21]|PRDATA[23]|PRDATA[27]|PRDATA[28]|PRDATA[29]|PRDATA[31]|PRDATA[9]|PSLVERR|VGND
+ D|X \$148
+ LO|PRDATA[10]|PRDATA[12]|PRDATA[13]|PRDATA[15]|PRDATA[16]|PRDATA[17]|PRDATA[18]|PRDATA[19]|PRDATA[21]|PRDATA[23]|PRDATA[27]|PRDATA[28]|PRDATA[29]|PRDATA[31]|PRDATA[9]|PSLVERR|VGND
+ sky130_fd_pr__nfet_01v8 L=0.15 W=0.42 AS=0.2205 AD=0.066 PS=1.89 PD=0.745
M$837 \$199 \$210 \$198
+ LO|PRDATA[10]|PRDATA[12]|PRDATA[13]|PRDATA[15]|PRDATA[16]|PRDATA[17]|PRDATA[18]|PRDATA[19]|PRDATA[21]|PRDATA[23]|PRDATA[27]|PRDATA[28]|PRDATA[29]|PRDATA[31]|PRDATA[9]|PSLVERR|VGND
+ sky130_fd_pr__nfet_01v8 L=0.15 W=0.42 AS=0.1401 AD=0.0441 PS=1.1 PD=0.63
M$838 \$198 PRESETn|RESET_B
+ LO|PRDATA[10]|PRDATA[12]|PRDATA[13]|PRDATA[15]|PRDATA[16]|PRDATA[17]|PRDATA[18]|PRDATA[19]|PRDATA[21]|PRDATA[23]|PRDATA[27]|PRDATA[28]|PRDATA[29]|PRDATA[31]|PRDATA[9]|PSLVERR|VGND
+ LO|PRDATA[10]|PRDATA[12]|PRDATA[13]|PRDATA[15]|PRDATA[16]|PRDATA[17]|PRDATA[18]|PRDATA[19]|PRDATA[21]|PRDATA[23]|PRDATA[27]|PRDATA[28]|PRDATA[29]|PRDATA[31]|PRDATA[9]|PSLVERR|VGND
+ sky130_fd_pr__nfet_01v8 L=0.15 W=0.42 AS=0.0441 AD=0.1346 PS=0.63 PD=1.15
M$839 \$197 \$151
+ LO|PRDATA[10]|PRDATA[12]|PRDATA[13]|PRDATA[15]|PRDATA[16]|PRDATA[17]|PRDATA[18]|PRDATA[19]|PRDATA[21]|PRDATA[23]|PRDATA[27]|PRDATA[28]|PRDATA[29]|PRDATA[31]|PRDATA[9]|PSLVERR|VGND
+ LO|PRDATA[10]|PRDATA[12]|PRDATA[13]|PRDATA[15]|PRDATA[16]|PRDATA[17]|PRDATA[18]|PRDATA[19]|PRDATA[21]|PRDATA[23]|PRDATA[27]|PRDATA[28]|PRDATA[29]|PRDATA[31]|PRDATA[9]|PSLVERR|VGND
+ sky130_fd_pr__nfet_01v8 L=0.15 W=0.42 AS=0.0669 AD=0.12495 PS=0.75 PD=1.015
M$840
+ LO|PRDATA[10]|PRDATA[12]|PRDATA[13]|PRDATA[15]|PRDATA[16]|PRDATA[17]|PRDATA[18]|PRDATA[19]|PRDATA[21]|PRDATA[23]|PRDATA[27]|PRDATA[28]|PRDATA[29]|PRDATA[31]|PRDATA[9]|PSLVERR|VGND
+ PRESETn|RESET_B \$196
+ LO|PRDATA[10]|PRDATA[12]|PRDATA[13]|PRDATA[15]|PRDATA[16]|PRDATA[17]|PRDATA[18]|PRDATA[19]|PRDATA[21]|PRDATA[23]|PRDATA[27]|PRDATA[28]|PRDATA[29]|PRDATA[31]|PRDATA[9]|PSLVERR|VGND
+ sky130_fd_pr__nfet_01v8 L=0.15 W=0.42 AS=0.12495 AD=0.06405 PS=1.015 PD=0.725
M$841 \$196 \$150 \$151
+ LO|PRDATA[10]|PRDATA[12]|PRDATA[13]|PRDATA[15]|PRDATA[16]|PRDATA[17]|PRDATA[18]|PRDATA[19]|PRDATA[21]|PRDATA[23]|PRDATA[27]|PRDATA[28]|PRDATA[29]|PRDATA[31]|PRDATA[9]|PSLVERR|VGND
+ sky130_fd_pr__nfet_01v8 L=0.15 W=0.42 AS=0.06405 AD=0.1092 PS=0.725 PD=1.36
M$842
+ LO|PRDATA[10]|PRDATA[12]|PRDATA[13]|PRDATA[15]|PRDATA[16]|PRDATA[17]|PRDATA[18]|PRDATA[19]|PRDATA[21]|PRDATA[23]|PRDATA[27]|PRDATA[28]|PRDATA[29]|PRDATA[31]|PRDATA[9]|PSLVERR|VGND
+ \$149 \$210
+ LO|PRDATA[10]|PRDATA[12]|PRDATA[13]|PRDATA[15]|PRDATA[16]|PRDATA[17]|PRDATA[18]|PRDATA[19]|PRDATA[21]|PRDATA[23]|PRDATA[27]|PRDATA[28]|PRDATA[29]|PRDATA[31]|PRDATA[9]|PSLVERR|VGND
+ sky130_fd_pr__nfet_01v8 L=0.15 W=0.64 AS=0.1346 AD=0.0999 PS=1.15 PD=0.985
M$843
+ LO|PRDATA[10]|PRDATA[12]|PRDATA[13]|PRDATA[15]|PRDATA[16]|PRDATA[17]|PRDATA[18]|PRDATA[19]|PRDATA[21]|PRDATA[23]|PRDATA[27]|PRDATA[28]|PRDATA[29]|PRDATA[31]|PRDATA[9]|PSLVERR|VGND
+ \$151 A0|A1|Q|gpio_out[3]
+ LO|PRDATA[10]|PRDATA[12]|PRDATA[13]|PRDATA[15]|PRDATA[16]|PRDATA[17]|PRDATA[18]|PRDATA[19]|PRDATA[21]|PRDATA[23]|PRDATA[27]|PRDATA[28]|PRDATA[29]|PRDATA[31]|PRDATA[9]|PSLVERR|VGND
+ sky130_fd_pr__nfet_01v8 L=0.15 W=0.65 AS=0.2087 AD=0.169 PS=2.02 PD=1.82
M$844
+ LO|PRDATA[10]|PRDATA[12]|PRDATA[13]|PRDATA[15]|PRDATA[16]|PRDATA[17]|PRDATA[18]|PRDATA[19]|PRDATA[21]|PRDATA[23]|PRDATA[27]|PRDATA[28]|PRDATA[29]|PRDATA[31]|PRDATA[9]|PSLVERR|VGND
+ S|X \$282
+ LO|PRDATA[10]|PRDATA[12]|PRDATA[13]|PRDATA[15]|PRDATA[16]|PRDATA[17]|PRDATA[18]|PRDATA[19]|PRDATA[21]|PRDATA[23]|PRDATA[27]|PRDATA[28]|PRDATA[29]|PRDATA[31]|PRDATA[9]|PSLVERR|VGND
+ sky130_fd_pr__nfet_01v8 L=0.15 W=0.42 AS=0.11285 AD=0.0693 PS=1.045 PD=0.75
M$845 \$282 A1|PWDATA[6] \$262
+ LO|PRDATA[10]|PRDATA[12]|PRDATA[13]|PRDATA[15]|PRDATA[16]|PRDATA[17]|PRDATA[18]|PRDATA[19]|PRDATA[21]|PRDATA[23]|PRDATA[27]|PRDATA[28]|PRDATA[29]|PRDATA[31]|PRDATA[9]|PSLVERR|VGND
+ sky130_fd_pr__nfet_01v8 L=0.15 W=0.42 AS=0.0693 AD=0.09975 PS=0.75 PD=0.895
M$846 \$262 A0|B2|Q|gpio_oe[6] \$285
+ LO|PRDATA[10]|PRDATA[12]|PRDATA[13]|PRDATA[15]|PRDATA[16]|PRDATA[17]|PRDATA[18]|PRDATA[19]|PRDATA[21]|PRDATA[23]|PRDATA[27]|PRDATA[28]|PRDATA[29]|PRDATA[31]|PRDATA[9]|PSLVERR|VGND
+ sky130_fd_pr__nfet_01v8 L=0.15 W=0.42 AS=0.09975 AD=0.0693 PS=0.895 PD=0.75
M$847 \$285 \$264
+ LO|PRDATA[10]|PRDATA[12]|PRDATA[13]|PRDATA[15]|PRDATA[16]|PRDATA[17]|PRDATA[18]|PRDATA[19]|PRDATA[21]|PRDATA[23]|PRDATA[27]|PRDATA[28]|PRDATA[29]|PRDATA[31]|PRDATA[9]|PSLVERR|VGND
+ LO|PRDATA[10]|PRDATA[12]|PRDATA[13]|PRDATA[15]|PRDATA[16]|PRDATA[17]|PRDATA[18]|PRDATA[19]|PRDATA[21]|PRDATA[23]|PRDATA[27]|PRDATA[28]|PRDATA[29]|PRDATA[31]|PRDATA[9]|PSLVERR|VGND
+ sky130_fd_pr__nfet_01v8 L=0.15 W=0.42 AS=0.0693 AD=0.1449 PS=0.75 PD=1.11
M$848
+ LO|PRDATA[10]|PRDATA[12]|PRDATA[13]|PRDATA[15]|PRDATA[16]|PRDATA[17]|PRDATA[18]|PRDATA[19]|PRDATA[21]|PRDATA[23]|PRDATA[27]|PRDATA[28]|PRDATA[29]|PRDATA[31]|PRDATA[9]|PSLVERR|VGND
+ S|X \$264
+ LO|PRDATA[10]|PRDATA[12]|PRDATA[13]|PRDATA[15]|PRDATA[16]|PRDATA[17]|PRDATA[18]|PRDATA[19]|PRDATA[21]|PRDATA[23]|PRDATA[27]|PRDATA[28]|PRDATA[29]|PRDATA[31]|PRDATA[9]|PSLVERR|VGND
+ sky130_fd_pr__nfet_01v8 L=0.15 W=0.42 AS=0.1449 AD=0.1092 PS=1.11 PD=1.36
M$849 A|X \$262
+ LO|PRDATA[10]|PRDATA[12]|PRDATA[13]|PRDATA[15]|PRDATA[16]|PRDATA[17]|PRDATA[18]|PRDATA[19]|PRDATA[21]|PRDATA[23]|PRDATA[27]|PRDATA[28]|PRDATA[29]|PRDATA[31]|PRDATA[9]|PSLVERR|VGND
+ LO|PRDATA[10]|PRDATA[12]|PRDATA[13]|PRDATA[15]|PRDATA[16]|PRDATA[17]|PRDATA[18]|PRDATA[19]|PRDATA[21]|PRDATA[23]|PRDATA[27]|PRDATA[28]|PRDATA[29]|PRDATA[31]|PRDATA[9]|PSLVERR|VGND
+ sky130_fd_pr__nfet_01v8 L=0.15 W=0.65 AS=0.169 AD=0.11285 PS=1.82 PD=1.045
M$850 \$223 A|X
+ LO|PRDATA[10]|PRDATA[12]|PRDATA[13]|PRDATA[15]|PRDATA[16]|PRDATA[17]|PRDATA[18]|PRDATA[19]|PRDATA[21]|PRDATA[23]|PRDATA[27]|PRDATA[28]|PRDATA[29]|PRDATA[31]|PRDATA[9]|PSLVERR|VGND
+ LO|PRDATA[10]|PRDATA[12]|PRDATA[13]|PRDATA[15]|PRDATA[16]|PRDATA[17]|PRDATA[18]|PRDATA[19]|PRDATA[21]|PRDATA[23]|PRDATA[27]|PRDATA[28]|PRDATA[29]|PRDATA[31]|PRDATA[9]|PSLVERR|VGND
+ sky130_fd_pr__nfet_01v8 L=0.15 W=0.65 AS=0.169 AD=0.08775 PS=1.82 PD=0.92
M$851
+ LO|PRDATA[10]|PRDATA[12]|PRDATA[13]|PRDATA[15]|PRDATA[16]|PRDATA[17]|PRDATA[18]|PRDATA[19]|PRDATA[21]|PRDATA[23]|PRDATA[27]|PRDATA[28]|PRDATA[29]|PRDATA[31]|PRDATA[9]|PSLVERR|VGND
+ \$223 D|X
+ LO|PRDATA[10]|PRDATA[12]|PRDATA[13]|PRDATA[15]|PRDATA[16]|PRDATA[17]|PRDATA[18]|PRDATA[19]|PRDATA[21]|PRDATA[23]|PRDATA[27]|PRDATA[28]|PRDATA[29]|PRDATA[31]|PRDATA[9]|PSLVERR|VGND
+ sky130_fd_pr__nfet_01v8 L=0.15 W=2.6 AS=0.351 AD=0.43225 PS=3.68 PD=4.58
M$855
+ LO|PRDATA[10]|PRDATA[12]|PRDATA[13]|PRDATA[15]|PRDATA[16]|PRDATA[17]|PRDATA[18]|PRDATA[19]|PRDATA[21]|PRDATA[23]|PRDATA[27]|PRDATA[28]|PRDATA[29]|PRDATA[31]|PRDATA[9]|PSLVERR|VGND
+ A|X \$265
+ LO|PRDATA[10]|PRDATA[12]|PRDATA[13]|PRDATA[15]|PRDATA[16]|PRDATA[17]|PRDATA[18]|PRDATA[19]|PRDATA[21]|PRDATA[23]|PRDATA[27]|PRDATA[28]|PRDATA[29]|PRDATA[31]|PRDATA[9]|PSLVERR|VGND
+ sky130_fd_pr__nfet_01v8 L=0.15 W=1.3 AS=0.25675 AD=0.1755 PS=2.74 PD=1.84
M$857
+ LO|PRDATA[10]|PRDATA[12]|PRDATA[13]|PRDATA[15]|PRDATA[16]|PRDATA[17]|PRDATA[18]|PRDATA[19]|PRDATA[21]|PRDATA[23]|PRDATA[27]|PRDATA[28]|PRDATA[29]|PRDATA[31]|PRDATA[9]|PSLVERR|VGND
+ \$265 D|X
+ LO|PRDATA[10]|PRDATA[12]|PRDATA[13]|PRDATA[15]|PRDATA[16]|PRDATA[17]|PRDATA[18]|PRDATA[19]|PRDATA[21]|PRDATA[23]|PRDATA[27]|PRDATA[28]|PRDATA[29]|PRDATA[31]|PRDATA[9]|PSLVERR|VGND
+ sky130_fd_pr__nfet_01v8 L=0.15 W=3.9 AS=0.5265 AD=0.60775 PS=5.52 PD=6.42
M$863 \$224 S|X
+ LO|PRDATA[10]|PRDATA[12]|PRDATA[13]|PRDATA[15]|PRDATA[16]|PRDATA[17]|PRDATA[18]|PRDATA[19]|PRDATA[21]|PRDATA[23]|PRDATA[27]|PRDATA[28]|PRDATA[29]|PRDATA[31]|PRDATA[9]|PSLVERR|VGND
+ LO|PRDATA[10]|PRDATA[12]|PRDATA[13]|PRDATA[15]|PRDATA[16]|PRDATA[17]|PRDATA[18]|PRDATA[19]|PRDATA[21]|PRDATA[23]|PRDATA[27]|PRDATA[28]|PRDATA[29]|PRDATA[31]|PRDATA[9]|PSLVERR|VGND
+ sky130_fd_pr__nfet_01v8 L=0.15 W=0.65 AS=0.169 AD=0.108875 PS=1.82 PD=0.985
M$864
+ LO|PRDATA[10]|PRDATA[12]|PRDATA[13]|PRDATA[15]|PRDATA[16]|PRDATA[17]|PRDATA[18]|PRDATA[19]|PRDATA[21]|PRDATA[23]|PRDATA[27]|PRDATA[28]|PRDATA[29]|PRDATA[31]|PRDATA[9]|PSLVERR|VGND
+ \$224 \$251
+ LO|PRDATA[10]|PRDATA[12]|PRDATA[13]|PRDATA[15]|PRDATA[16]|PRDATA[17]|PRDATA[18]|PRDATA[19]|PRDATA[21]|PRDATA[23]|PRDATA[27]|PRDATA[28]|PRDATA[29]|PRDATA[31]|PRDATA[9]|PSLVERR|VGND
+ sky130_fd_pr__nfet_01v8 L=0.15 W=0.65 AS=0.108875 AD=0.26 PS=0.985 PD=1.45
M$865 \$251 A0|A1|Q|gpio_out[0] \$227
+ LO|PRDATA[10]|PRDATA[12]|PRDATA[13]|PRDATA[15]|PRDATA[16]|PRDATA[17]|PRDATA[18]|PRDATA[19]|PRDATA[21]|PRDATA[23]|PRDATA[27]|PRDATA[28]|PRDATA[29]|PRDATA[31]|PRDATA[9]|PSLVERR|VGND
+ sky130_fd_pr__nfet_01v8 L=0.15 W=0.65 AS=0.26 AD=0.104 PS=1.45 PD=0.97
M$866 \$227 A1|PWDATA[0] \$252
+ LO|PRDATA[10]|PRDATA[12]|PRDATA[13]|PRDATA[15]|PRDATA[16]|PRDATA[17]|PRDATA[18]|PRDATA[19]|PRDATA[21]|PRDATA[23]|PRDATA[27]|PRDATA[28]|PRDATA[29]|PRDATA[31]|PRDATA[9]|PSLVERR|VGND
+ sky130_fd_pr__nfet_01v8 L=0.15 W=0.65 AS=0.104 AD=0.274625 PS=0.97 PD=1.495
M$867 \$252 S|X
+ LO|PRDATA[10]|PRDATA[12]|PRDATA[13]|PRDATA[15]|PRDATA[16]|PRDATA[17]|PRDATA[18]|PRDATA[19]|PRDATA[21]|PRDATA[23]|PRDATA[27]|PRDATA[28]|PRDATA[29]|PRDATA[31]|PRDATA[9]|PSLVERR|VGND
+ LO|PRDATA[10]|PRDATA[12]|PRDATA[13]|PRDATA[15]|PRDATA[16]|PRDATA[17]|PRDATA[18]|PRDATA[19]|PRDATA[21]|PRDATA[23]|PRDATA[27]|PRDATA[28]|PRDATA[29]|PRDATA[31]|PRDATA[9]|PSLVERR|VGND
+ sky130_fd_pr__nfet_01v8 L=0.15 W=0.65 AS=0.274625 AD=0.08775 PS=1.495 PD=0.92
M$868
+ LO|PRDATA[10]|PRDATA[12]|PRDATA[13]|PRDATA[15]|PRDATA[16]|PRDATA[17]|PRDATA[18]|PRDATA[19]|PRDATA[21]|PRDATA[23]|PRDATA[27]|PRDATA[28]|PRDATA[29]|PRDATA[31]|PRDATA[9]|PSLVERR|VGND
+ \$227 A|X
+ LO|PRDATA[10]|PRDATA[12]|PRDATA[13]|PRDATA[15]|PRDATA[16]|PRDATA[17]|PRDATA[18]|PRDATA[19]|PRDATA[21]|PRDATA[23]|PRDATA[27]|PRDATA[28]|PRDATA[29]|PRDATA[31]|PRDATA[9]|PSLVERR|VGND
+ sky130_fd_pr__nfet_01v8 L=0.15 W=2.6 AS=0.351 AD=0.43225 PS=3.68 PD=4.58
M$872 \$229 CLK|X
+ LO|PRDATA[10]|PRDATA[12]|PRDATA[13]|PRDATA[15]|PRDATA[16]|PRDATA[17]|PRDATA[18]|PRDATA[19]|PRDATA[21]|PRDATA[23]|PRDATA[27]|PRDATA[28]|PRDATA[29]|PRDATA[31]|PRDATA[9]|PSLVERR|VGND
+ LO|PRDATA[10]|PRDATA[12]|PRDATA[13]|PRDATA[15]|PRDATA[16]|PRDATA[17]|PRDATA[18]|PRDATA[19]|PRDATA[21]|PRDATA[23]|PRDATA[27]|PRDATA[28]|PRDATA[29]|PRDATA[31]|PRDATA[9]|PSLVERR|VGND
+ sky130_fd_pr__nfet_01v8 L=0.15 W=0.42 AS=0.1092 AD=0.0567 PS=1.36 PD=0.69
M$873
+ LO|PRDATA[10]|PRDATA[12]|PRDATA[13]|PRDATA[15]|PRDATA[16]|PRDATA[17]|PRDATA[18]|PRDATA[19]|PRDATA[21]|PRDATA[23]|PRDATA[27]|PRDATA[28]|PRDATA[29]|PRDATA[31]|PRDATA[9]|PSLVERR|VGND
+ \$229 \$230
+ LO|PRDATA[10]|PRDATA[12]|PRDATA[13]|PRDATA[15]|PRDATA[16]|PRDATA[17]|PRDATA[18]|PRDATA[19]|PRDATA[21]|PRDATA[23]|PRDATA[27]|PRDATA[28]|PRDATA[29]|PRDATA[31]|PRDATA[9]|PSLVERR|VGND
+ sky130_fd_pr__nfet_01v8 L=0.15 W=0.42 AS=0.0567 AD=0.1092 PS=0.69 PD=1.36
M$874
+ LO|PRDATA[10]|PRDATA[12]|PRDATA[13]|PRDATA[15]|PRDATA[16]|PRDATA[17]|PRDATA[18]|PRDATA[19]|PRDATA[21]|PRDATA[23]|PRDATA[27]|PRDATA[28]|PRDATA[29]|PRDATA[31]|PRDATA[9]|PSLVERR|VGND
+ D|X \$232
+ LO|PRDATA[10]|PRDATA[12]|PRDATA[13]|PRDATA[15]|PRDATA[16]|PRDATA[17]|PRDATA[18]|PRDATA[19]|PRDATA[21]|PRDATA[23]|PRDATA[27]|PRDATA[28]|PRDATA[29]|PRDATA[31]|PRDATA[9]|PSLVERR|VGND
+ sky130_fd_pr__nfet_01v8 L=0.15 W=0.42 AS=0.2205 AD=0.066 PS=1.89 PD=0.745
M$875 \$232 \$229 \$233
+ LO|PRDATA[10]|PRDATA[12]|PRDATA[13]|PRDATA[15]|PRDATA[16]|PRDATA[17]|PRDATA[18]|PRDATA[19]|PRDATA[21]|PRDATA[23]|PRDATA[27]|PRDATA[28]|PRDATA[29]|PRDATA[31]|PRDATA[9]|PSLVERR|VGND
+ sky130_fd_pr__nfet_01v8 L=0.15 W=0.36 AS=0.066 AD=0.0594 PS=0.745 PD=0.69
M$876 \$254 \$230 \$233
+ LO|PRDATA[10]|PRDATA[12]|PRDATA[13]|PRDATA[15]|PRDATA[16]|PRDATA[17]|PRDATA[18]|PRDATA[19]|PRDATA[21]|PRDATA[23]|PRDATA[27]|PRDATA[28]|PRDATA[29]|PRDATA[31]|PRDATA[9]|PSLVERR|VGND
+ sky130_fd_pr__nfet_01v8 L=0.15 W=0.36 AS=0.1401 AD=0.0594 PS=1.1 PD=0.69
M$877 \$254 \$235 \$255
+ LO|PRDATA[10]|PRDATA[12]|PRDATA[13]|PRDATA[15]|PRDATA[16]|PRDATA[17]|PRDATA[18]|PRDATA[19]|PRDATA[21]|PRDATA[23]|PRDATA[27]|PRDATA[28]|PRDATA[29]|PRDATA[31]|PRDATA[9]|PSLVERR|VGND
+ sky130_fd_pr__nfet_01v8 L=0.15 W=0.42 AS=0.1401 AD=0.0441 PS=1.1 PD=0.63
M$878
+ LO|PRDATA[10]|PRDATA[12]|PRDATA[13]|PRDATA[15]|PRDATA[16]|PRDATA[17]|PRDATA[18]|PRDATA[19]|PRDATA[21]|PRDATA[23]|PRDATA[27]|PRDATA[28]|PRDATA[29]|PRDATA[31]|PRDATA[9]|PSLVERR|VGND
+ PRESETn|RESET_B \$255
+ LO|PRDATA[10]|PRDATA[12]|PRDATA[13]|PRDATA[15]|PRDATA[16]|PRDATA[17]|PRDATA[18]|PRDATA[19]|PRDATA[21]|PRDATA[23]|PRDATA[27]|PRDATA[28]|PRDATA[29]|PRDATA[31]|PRDATA[9]|PSLVERR|VGND
+ sky130_fd_pr__nfet_01v8 L=0.15 W=0.42 AS=0.1346 AD=0.0441 PS=1.15 PD=0.63
M$879
+ LO|PRDATA[10]|PRDATA[12]|PRDATA[13]|PRDATA[15]|PRDATA[16]|PRDATA[17]|PRDATA[18]|PRDATA[19]|PRDATA[21]|PRDATA[23]|PRDATA[27]|PRDATA[28]|PRDATA[29]|PRDATA[31]|PRDATA[9]|PSLVERR|VGND
+ \$233 \$235
+ LO|PRDATA[10]|PRDATA[12]|PRDATA[13]|PRDATA[15]|PRDATA[16]|PRDATA[17]|PRDATA[18]|PRDATA[19]|PRDATA[21]|PRDATA[23]|PRDATA[27]|PRDATA[28]|PRDATA[29]|PRDATA[31]|PRDATA[9]|PSLVERR|VGND
+ sky130_fd_pr__nfet_01v8 L=0.15 W=0.64 AS=0.1346 AD=0.0999 PS=1.15 PD=0.985
M$880 \$235 \$230 \$236
+ LO|PRDATA[10]|PRDATA[12]|PRDATA[13]|PRDATA[15]|PRDATA[16]|PRDATA[17]|PRDATA[18]|PRDATA[19]|PRDATA[21]|PRDATA[23]|PRDATA[27]|PRDATA[28]|PRDATA[29]|PRDATA[31]|PRDATA[9]|PSLVERR|VGND
+ sky130_fd_pr__nfet_01v8 L=0.15 W=0.36 AS=0.0999 AD=0.0711 PS=0.985 PD=0.755
M$881 \$256 \$229 \$236
+ LO|PRDATA[10]|PRDATA[12]|PRDATA[13]|PRDATA[15]|PRDATA[16]|PRDATA[17]|PRDATA[18]|PRDATA[19]|PRDATA[21]|PRDATA[23]|PRDATA[27]|PRDATA[28]|PRDATA[29]|PRDATA[31]|PRDATA[9]|PSLVERR|VGND
+ sky130_fd_pr__nfet_01v8 L=0.15 W=0.36 AS=0.0669 AD=0.0711 PS=0.75 PD=0.755
M$882 \$256 \$237
+ LO|PRDATA[10]|PRDATA[12]|PRDATA[13]|PRDATA[15]|PRDATA[16]|PRDATA[17]|PRDATA[18]|PRDATA[19]|PRDATA[21]|PRDATA[23]|PRDATA[27]|PRDATA[28]|PRDATA[29]|PRDATA[31]|PRDATA[9]|PSLVERR|VGND
+ LO|PRDATA[10]|PRDATA[12]|PRDATA[13]|PRDATA[15]|PRDATA[16]|PRDATA[17]|PRDATA[18]|PRDATA[19]|PRDATA[21]|PRDATA[23]|PRDATA[27]|PRDATA[28]|PRDATA[29]|PRDATA[31]|PRDATA[9]|PSLVERR|VGND
+ sky130_fd_pr__nfet_01v8 L=0.15 W=0.42 AS=0.0669 AD=0.12495 PS=0.75 PD=1.015
M$883
+ LO|PRDATA[10]|PRDATA[12]|PRDATA[13]|PRDATA[15]|PRDATA[16]|PRDATA[17]|PRDATA[18]|PRDATA[19]|PRDATA[21]|PRDATA[23]|PRDATA[27]|PRDATA[28]|PRDATA[29]|PRDATA[31]|PRDATA[9]|PSLVERR|VGND
+ PRESETn|RESET_B \$257
+ LO|PRDATA[10]|PRDATA[12]|PRDATA[13]|PRDATA[15]|PRDATA[16]|PRDATA[17]|PRDATA[18]|PRDATA[19]|PRDATA[21]|PRDATA[23]|PRDATA[27]|PRDATA[28]|PRDATA[29]|PRDATA[31]|PRDATA[9]|PSLVERR|VGND
+ sky130_fd_pr__nfet_01v8 L=0.15 W=0.42 AS=0.12495 AD=0.06405 PS=1.015 PD=0.725
M$884 \$257 \$236 \$237
+ LO|PRDATA[10]|PRDATA[12]|PRDATA[13]|PRDATA[15]|PRDATA[16]|PRDATA[17]|PRDATA[18]|PRDATA[19]|PRDATA[21]|PRDATA[23]|PRDATA[27]|PRDATA[28]|PRDATA[29]|PRDATA[31]|PRDATA[9]|PSLVERR|VGND
+ sky130_fd_pr__nfet_01v8 L=0.15 W=0.42 AS=0.06405 AD=0.1092 PS=0.725 PD=1.36
M$885 \$266 A|X
+ LO|PRDATA[10]|PRDATA[12]|PRDATA[13]|PRDATA[15]|PRDATA[16]|PRDATA[17]|PRDATA[18]|PRDATA[19]|PRDATA[21]|PRDATA[23]|PRDATA[27]|PRDATA[28]|PRDATA[29]|PRDATA[31]|PRDATA[9]|PSLVERR|VGND
+ LO|PRDATA[10]|PRDATA[12]|PRDATA[13]|PRDATA[15]|PRDATA[16]|PRDATA[17]|PRDATA[18]|PRDATA[19]|PRDATA[21]|PRDATA[23]|PRDATA[27]|PRDATA[28]|PRDATA[29]|PRDATA[31]|PRDATA[9]|PSLVERR|VGND
+ sky130_fd_pr__nfet_01v8 L=0.15 W=0.65 AS=0.169 AD=0.08775 PS=1.82 PD=0.92
M$886
+ LO|PRDATA[10]|PRDATA[12]|PRDATA[13]|PRDATA[15]|PRDATA[16]|PRDATA[17]|PRDATA[18]|PRDATA[19]|PRDATA[21]|PRDATA[23]|PRDATA[27]|PRDATA[28]|PRDATA[29]|PRDATA[31]|PRDATA[9]|PSLVERR|VGND
+ \$266 D|X
+ LO|PRDATA[10]|PRDATA[12]|PRDATA[13]|PRDATA[15]|PRDATA[16]|PRDATA[17]|PRDATA[18]|PRDATA[19]|PRDATA[21]|PRDATA[23]|PRDATA[27]|PRDATA[28]|PRDATA[29]|PRDATA[31]|PRDATA[9]|PSLVERR|VGND
+ sky130_fd_pr__nfet_01v8 L=0.15 W=2.6 AS=0.351 AD=0.43225 PS=3.68 PD=4.58
M$890 \$267 CLK|X
+ LO|PRDATA[10]|PRDATA[12]|PRDATA[13]|PRDATA[15]|PRDATA[16]|PRDATA[17]|PRDATA[18]|PRDATA[19]|PRDATA[21]|PRDATA[23]|PRDATA[27]|PRDATA[28]|PRDATA[29]|PRDATA[31]|PRDATA[9]|PSLVERR|VGND
+ LO|PRDATA[10]|PRDATA[12]|PRDATA[13]|PRDATA[15]|PRDATA[16]|PRDATA[17]|PRDATA[18]|PRDATA[19]|PRDATA[21]|PRDATA[23]|PRDATA[27]|PRDATA[28]|PRDATA[29]|PRDATA[31]|PRDATA[9]|PSLVERR|VGND
+ sky130_fd_pr__nfet_01v8 L=0.15 W=0.42 AS=0.1092 AD=0.0567 PS=1.36 PD=0.69
M$891
+ LO|PRDATA[10]|PRDATA[12]|PRDATA[13]|PRDATA[15]|PRDATA[16]|PRDATA[17]|PRDATA[18]|PRDATA[19]|PRDATA[21]|PRDATA[23]|PRDATA[27]|PRDATA[28]|PRDATA[29]|PRDATA[31]|PRDATA[9]|PSLVERR|VGND
+ \$267 \$268
+ LO|PRDATA[10]|PRDATA[12]|PRDATA[13]|PRDATA[15]|PRDATA[16]|PRDATA[17]|PRDATA[18]|PRDATA[19]|PRDATA[21]|PRDATA[23]|PRDATA[27]|PRDATA[28]|PRDATA[29]|PRDATA[31]|PRDATA[9]|PSLVERR|VGND
+ sky130_fd_pr__nfet_01v8 L=0.15 W=0.42 AS=0.0567 AD=0.1092 PS=0.69 PD=1.36
M$892 \$269 \$267 \$270
+ LO|PRDATA[10]|PRDATA[12]|PRDATA[13]|PRDATA[15]|PRDATA[16]|PRDATA[17]|PRDATA[18]|PRDATA[19]|PRDATA[21]|PRDATA[23]|PRDATA[27]|PRDATA[28]|PRDATA[29]|PRDATA[31]|PRDATA[9]|PSLVERR|VGND
+ sky130_fd_pr__nfet_01v8 L=0.15 W=0.36 AS=0.066 AD=0.0594 PS=0.745 PD=0.69
M$893 \$270 \$268 \$308
+ LO|PRDATA[10]|PRDATA[12]|PRDATA[13]|PRDATA[15]|PRDATA[16]|PRDATA[17]|PRDATA[18]|PRDATA[19]|PRDATA[21]|PRDATA[23]|PRDATA[27]|PRDATA[28]|PRDATA[29]|PRDATA[31]|PRDATA[9]|PSLVERR|VGND
+ sky130_fd_pr__nfet_01v8 L=0.15 W=0.36 AS=0.0594 AD=0.1401 PS=0.69 PD=1.1
M$894 \$326 \$268 \$271
+ LO|PRDATA[10]|PRDATA[12]|PRDATA[13]|PRDATA[15]|PRDATA[16]|PRDATA[17]|PRDATA[18]|PRDATA[19]|PRDATA[21]|PRDATA[23]|PRDATA[27]|PRDATA[28]|PRDATA[29]|PRDATA[31]|PRDATA[9]|PSLVERR|VGND
+ sky130_fd_pr__nfet_01v8 L=0.15 W=0.36 AS=0.0999 AD=0.0711 PS=0.985 PD=0.755
M$895 \$271 \$267 \$312
+ LO|PRDATA[10]|PRDATA[12]|PRDATA[13]|PRDATA[15]|PRDATA[16]|PRDATA[17]|PRDATA[18]|PRDATA[19]|PRDATA[21]|PRDATA[23]|PRDATA[27]|PRDATA[28]|PRDATA[29]|PRDATA[31]|PRDATA[9]|PSLVERR|VGND
+ sky130_fd_pr__nfet_01v8 L=0.15 W=0.36 AS=0.0711 AD=0.0669 PS=0.755 PD=0.75
M$896
+ LO|PRDATA[10]|PRDATA[12]|PRDATA[13]|PRDATA[15]|PRDATA[16]|PRDATA[17]|PRDATA[18]|PRDATA[19]|PRDATA[21]|PRDATA[23]|PRDATA[27]|PRDATA[28]|PRDATA[29]|PRDATA[31]|PRDATA[9]|PSLVERR|VGND
+ D|X \$269
+ LO|PRDATA[10]|PRDATA[12]|PRDATA[13]|PRDATA[15]|PRDATA[16]|PRDATA[17]|PRDATA[18]|PRDATA[19]|PRDATA[21]|PRDATA[23]|PRDATA[27]|PRDATA[28]|PRDATA[29]|PRDATA[31]|PRDATA[9]|PSLVERR|VGND
+ sky130_fd_pr__nfet_01v8 L=0.15 W=0.42 AS=0.2205 AD=0.066 PS=1.89 PD=0.745
M$897 \$308 \$326 \$310
+ LO|PRDATA[10]|PRDATA[12]|PRDATA[13]|PRDATA[15]|PRDATA[16]|PRDATA[17]|PRDATA[18]|PRDATA[19]|PRDATA[21]|PRDATA[23]|PRDATA[27]|PRDATA[28]|PRDATA[29]|PRDATA[31]|PRDATA[9]|PSLVERR|VGND
+ sky130_fd_pr__nfet_01v8 L=0.15 W=0.42 AS=0.1401 AD=0.0441 PS=1.1 PD=0.63
M$898 \$310 PRESETn|RESET_B
+ LO|PRDATA[10]|PRDATA[12]|PRDATA[13]|PRDATA[15]|PRDATA[16]|PRDATA[17]|PRDATA[18]|PRDATA[19]|PRDATA[21]|PRDATA[23]|PRDATA[27]|PRDATA[28]|PRDATA[29]|PRDATA[31]|PRDATA[9]|PSLVERR|VGND
+ LO|PRDATA[10]|PRDATA[12]|PRDATA[13]|PRDATA[15]|PRDATA[16]|PRDATA[17]|PRDATA[18]|PRDATA[19]|PRDATA[21]|PRDATA[23]|PRDATA[27]|PRDATA[28]|PRDATA[29]|PRDATA[31]|PRDATA[9]|PSLVERR|VGND
+ sky130_fd_pr__nfet_01v8 L=0.15 W=0.42 AS=0.0441 AD=0.1346 PS=0.63 PD=1.15
M$899 \$312 \$272
+ LO|PRDATA[10]|PRDATA[12]|PRDATA[13]|PRDATA[15]|PRDATA[16]|PRDATA[17]|PRDATA[18]|PRDATA[19]|PRDATA[21]|PRDATA[23]|PRDATA[27]|PRDATA[28]|PRDATA[29]|PRDATA[31]|PRDATA[9]|PSLVERR|VGND
+ LO|PRDATA[10]|PRDATA[12]|PRDATA[13]|PRDATA[15]|PRDATA[16]|PRDATA[17]|PRDATA[18]|PRDATA[19]|PRDATA[21]|PRDATA[23]|PRDATA[27]|PRDATA[28]|PRDATA[29]|PRDATA[31]|PRDATA[9]|PSLVERR|VGND
+ sky130_fd_pr__nfet_01v8 L=0.15 W=0.42 AS=0.0669 AD=0.12495 PS=0.75 PD=1.015
M$900
+ LO|PRDATA[10]|PRDATA[12]|PRDATA[13]|PRDATA[15]|PRDATA[16]|PRDATA[17]|PRDATA[18]|PRDATA[19]|PRDATA[21]|PRDATA[23]|PRDATA[27]|PRDATA[28]|PRDATA[29]|PRDATA[31]|PRDATA[9]|PSLVERR|VGND
+ PRESETn|RESET_B \$314
+ LO|PRDATA[10]|PRDATA[12]|PRDATA[13]|PRDATA[15]|PRDATA[16]|PRDATA[17]|PRDATA[18]|PRDATA[19]|PRDATA[21]|PRDATA[23]|PRDATA[27]|PRDATA[28]|PRDATA[29]|PRDATA[31]|PRDATA[9]|PSLVERR|VGND
+ sky130_fd_pr__nfet_01v8 L=0.15 W=0.42 AS=0.12495 AD=0.06405 PS=1.015 PD=0.725
M$901 \$314 \$271 \$272
+ LO|PRDATA[10]|PRDATA[12]|PRDATA[13]|PRDATA[15]|PRDATA[16]|PRDATA[17]|PRDATA[18]|PRDATA[19]|PRDATA[21]|PRDATA[23]|PRDATA[27]|PRDATA[28]|PRDATA[29]|PRDATA[31]|PRDATA[9]|PSLVERR|VGND
+ sky130_fd_pr__nfet_01v8 L=0.15 W=0.42 AS=0.06405 AD=0.1092 PS=0.725 PD=1.36
M$902
+ LO|PRDATA[10]|PRDATA[12]|PRDATA[13]|PRDATA[15]|PRDATA[16]|PRDATA[17]|PRDATA[18]|PRDATA[19]|PRDATA[21]|PRDATA[23]|PRDATA[27]|PRDATA[28]|PRDATA[29]|PRDATA[31]|PRDATA[9]|PSLVERR|VGND
+ \$270 \$326
+ LO|PRDATA[10]|PRDATA[12]|PRDATA[13]|PRDATA[15]|PRDATA[16]|PRDATA[17]|PRDATA[18]|PRDATA[19]|PRDATA[21]|PRDATA[23]|PRDATA[27]|PRDATA[28]|PRDATA[29]|PRDATA[31]|PRDATA[9]|PSLVERR|VGND
+ sky130_fd_pr__nfet_01v8 L=0.15 W=0.64 AS=0.1346 AD=0.0999 PS=1.15 PD=0.985
M$903
+ LO|PRDATA[10]|PRDATA[12]|PRDATA[13]|PRDATA[15]|PRDATA[16]|PRDATA[17]|PRDATA[18]|PRDATA[19]|PRDATA[21]|PRDATA[23]|PRDATA[27]|PRDATA[28]|PRDATA[29]|PRDATA[31]|PRDATA[9]|PSLVERR|VGND
+ \$237 A0|B2|Q|gpio_oe[1]
+ LO|PRDATA[10]|PRDATA[12]|PRDATA[13]|PRDATA[15]|PRDATA[16]|PRDATA[17]|PRDATA[18]|PRDATA[19]|PRDATA[21]|PRDATA[23]|PRDATA[27]|PRDATA[28]|PRDATA[29]|PRDATA[31]|PRDATA[9]|PSLVERR|VGND
+ sky130_fd_pr__nfet_01v8 L=0.15 W=0.65 AS=0.2087 AD=0.169 PS=2.02 PD=1.82
M$904
+ LO|PRDATA[10]|PRDATA[12]|PRDATA[13]|PRDATA[15]|PRDATA[16]|PRDATA[17]|PRDATA[18]|PRDATA[19]|PRDATA[21]|PRDATA[23]|PRDATA[27]|PRDATA[28]|PRDATA[29]|PRDATA[31]|PRDATA[9]|PSLVERR|VGND
+ \$272 A0|A1|Q|gpio_out[1]
+ LO|PRDATA[10]|PRDATA[12]|PRDATA[13]|PRDATA[15]|PRDATA[16]|PRDATA[17]|PRDATA[18]|PRDATA[19]|PRDATA[21]|PRDATA[23]|PRDATA[27]|PRDATA[28]|PRDATA[29]|PRDATA[31]|PRDATA[9]|PSLVERR|VGND
+ sky130_fd_pr__nfet_01v8 L=0.15 W=0.65 AS=0.2087 AD=0.169 PS=2.02 PD=1.82
M$905 \$238 A|X
+ LO|PRDATA[10]|PRDATA[12]|PRDATA[13]|PRDATA[15]|PRDATA[16]|PRDATA[17]|PRDATA[18]|PRDATA[19]|PRDATA[21]|PRDATA[23]|PRDATA[27]|PRDATA[28]|PRDATA[29]|PRDATA[31]|PRDATA[9]|PSLVERR|VGND
+ LO|PRDATA[10]|PRDATA[12]|PRDATA[13]|PRDATA[15]|PRDATA[16]|PRDATA[17]|PRDATA[18]|PRDATA[19]|PRDATA[21]|PRDATA[23]|PRDATA[27]|PRDATA[28]|PRDATA[29]|PRDATA[31]|PRDATA[9]|PSLVERR|VGND
+ sky130_fd_pr__nfet_01v8 L=0.15 W=0.65 AS=0.169 AD=0.08775 PS=1.82 PD=0.92
M$906
+ LO|PRDATA[10]|PRDATA[12]|PRDATA[13]|PRDATA[15]|PRDATA[16]|PRDATA[17]|PRDATA[18]|PRDATA[19]|PRDATA[21]|PRDATA[23]|PRDATA[27]|PRDATA[28]|PRDATA[29]|PRDATA[31]|PRDATA[9]|PSLVERR|VGND
+ \$238 D|X
+ LO|PRDATA[10]|PRDATA[12]|PRDATA[13]|PRDATA[15]|PRDATA[16]|PRDATA[17]|PRDATA[18]|PRDATA[19]|PRDATA[21]|PRDATA[23]|PRDATA[27]|PRDATA[28]|PRDATA[29]|PRDATA[31]|PRDATA[9]|PSLVERR|VGND
+ sky130_fd_pr__nfet_01v8 L=0.15 W=2.6 AS=0.351 AD=0.43225 PS=3.68 PD=4.58
M$910
+ LO|PRDATA[10]|PRDATA[12]|PRDATA[13]|PRDATA[15]|PRDATA[16]|PRDATA[17]|PRDATA[18]|PRDATA[19]|PRDATA[21]|PRDATA[23]|PRDATA[27]|PRDATA[28]|PRDATA[29]|PRDATA[31]|PRDATA[9]|PSLVERR|VGND
+ S|X \$320
+ LO|PRDATA[10]|PRDATA[12]|PRDATA[13]|PRDATA[15]|PRDATA[16]|PRDATA[17]|PRDATA[18]|PRDATA[19]|PRDATA[21]|PRDATA[23]|PRDATA[27]|PRDATA[28]|PRDATA[29]|PRDATA[31]|PRDATA[9]|PSLVERR|VGND
+ sky130_fd_pr__nfet_01v8 L=0.15 W=0.42 AS=0.11285 AD=0.0693 PS=1.045 PD=0.75
M$911 \$320 A1|PWDATA[3] \$273
+ LO|PRDATA[10]|PRDATA[12]|PRDATA[13]|PRDATA[15]|PRDATA[16]|PRDATA[17]|PRDATA[18]|PRDATA[19]|PRDATA[21]|PRDATA[23]|PRDATA[27]|PRDATA[28]|PRDATA[29]|PRDATA[31]|PRDATA[9]|PSLVERR|VGND
+ sky130_fd_pr__nfet_01v8 L=0.15 W=0.42 AS=0.0693 AD=0.09975 PS=0.75 PD=0.895
M$912 \$273 A0|B2|Q|gpio_oe[3] \$322
+ LO|PRDATA[10]|PRDATA[12]|PRDATA[13]|PRDATA[15]|PRDATA[16]|PRDATA[17]|PRDATA[18]|PRDATA[19]|PRDATA[21]|PRDATA[23]|PRDATA[27]|PRDATA[28]|PRDATA[29]|PRDATA[31]|PRDATA[9]|PSLVERR|VGND
+ sky130_fd_pr__nfet_01v8 L=0.15 W=0.42 AS=0.09975 AD=0.0693 PS=0.895 PD=0.75
M$913 \$322 \$274
+ LO|PRDATA[10]|PRDATA[12]|PRDATA[13]|PRDATA[15]|PRDATA[16]|PRDATA[17]|PRDATA[18]|PRDATA[19]|PRDATA[21]|PRDATA[23]|PRDATA[27]|PRDATA[28]|PRDATA[29]|PRDATA[31]|PRDATA[9]|PSLVERR|VGND
+ LO|PRDATA[10]|PRDATA[12]|PRDATA[13]|PRDATA[15]|PRDATA[16]|PRDATA[17]|PRDATA[18]|PRDATA[19]|PRDATA[21]|PRDATA[23]|PRDATA[27]|PRDATA[28]|PRDATA[29]|PRDATA[31]|PRDATA[9]|PSLVERR|VGND
+ sky130_fd_pr__nfet_01v8 L=0.15 W=0.42 AS=0.0693 AD=0.1449 PS=0.75 PD=1.11
M$914
+ LO|PRDATA[10]|PRDATA[12]|PRDATA[13]|PRDATA[15]|PRDATA[16]|PRDATA[17]|PRDATA[18]|PRDATA[19]|PRDATA[21]|PRDATA[23]|PRDATA[27]|PRDATA[28]|PRDATA[29]|PRDATA[31]|PRDATA[9]|PSLVERR|VGND
+ S|X \$274
+ LO|PRDATA[10]|PRDATA[12]|PRDATA[13]|PRDATA[15]|PRDATA[16]|PRDATA[17]|PRDATA[18]|PRDATA[19]|PRDATA[21]|PRDATA[23]|PRDATA[27]|PRDATA[28]|PRDATA[29]|PRDATA[31]|PRDATA[9]|PSLVERR|VGND
+ sky130_fd_pr__nfet_01v8 L=0.15 W=0.42 AS=0.1449 AD=0.1092 PS=1.11 PD=1.36
M$915 A|X \$273
+ LO|PRDATA[10]|PRDATA[12]|PRDATA[13]|PRDATA[15]|PRDATA[16]|PRDATA[17]|PRDATA[18]|PRDATA[19]|PRDATA[21]|PRDATA[23]|PRDATA[27]|PRDATA[28]|PRDATA[29]|PRDATA[31]|PRDATA[9]|PSLVERR|VGND
+ LO|PRDATA[10]|PRDATA[12]|PRDATA[13]|PRDATA[15]|PRDATA[16]|PRDATA[17]|PRDATA[18]|PRDATA[19]|PRDATA[21]|PRDATA[23]|PRDATA[27]|PRDATA[28]|PRDATA[29]|PRDATA[31]|PRDATA[9]|PSLVERR|VGND
+ sky130_fd_pr__nfet_01v8 L=0.15 W=0.65 AS=0.169 AD=0.11285 PS=1.82 PD=1.045
M$916 \$239 S|X
+ LO|PRDATA[10]|PRDATA[12]|PRDATA[13]|PRDATA[15]|PRDATA[16]|PRDATA[17]|PRDATA[18]|PRDATA[19]|PRDATA[21]|PRDATA[23]|PRDATA[27]|PRDATA[28]|PRDATA[29]|PRDATA[31]|PRDATA[9]|PSLVERR|VGND
+ LO|PRDATA[10]|PRDATA[12]|PRDATA[13]|PRDATA[15]|PRDATA[16]|PRDATA[17]|PRDATA[18]|PRDATA[19]|PRDATA[21]|PRDATA[23]|PRDATA[27]|PRDATA[28]|PRDATA[29]|PRDATA[31]|PRDATA[9]|PSLVERR|VGND
+ sky130_fd_pr__nfet_01v8 L=0.15 W=0.65 AS=0.169 AD=0.108875 PS=1.82 PD=0.985
M$917
+ LO|PRDATA[10]|PRDATA[12]|PRDATA[13]|PRDATA[15]|PRDATA[16]|PRDATA[17]|PRDATA[18]|PRDATA[19]|PRDATA[21]|PRDATA[23]|PRDATA[27]|PRDATA[28]|PRDATA[29]|PRDATA[31]|PRDATA[9]|PSLVERR|VGND
+ \$239 \$259
+ LO|PRDATA[10]|PRDATA[12]|PRDATA[13]|PRDATA[15]|PRDATA[16]|PRDATA[17]|PRDATA[18]|PRDATA[19]|PRDATA[21]|PRDATA[23]|PRDATA[27]|PRDATA[28]|PRDATA[29]|PRDATA[31]|PRDATA[9]|PSLVERR|VGND
+ sky130_fd_pr__nfet_01v8 L=0.15 W=0.65 AS=0.108875 AD=0.26 PS=0.985 PD=1.45
M$918 \$259 A0|A1|Q|gpio_out[3] \$242
+ LO|PRDATA[10]|PRDATA[12]|PRDATA[13]|PRDATA[15]|PRDATA[16]|PRDATA[17]|PRDATA[18]|PRDATA[19]|PRDATA[21]|PRDATA[23]|PRDATA[27]|PRDATA[28]|PRDATA[29]|PRDATA[31]|PRDATA[9]|PSLVERR|VGND
+ sky130_fd_pr__nfet_01v8 L=0.15 W=0.65 AS=0.26 AD=0.104 PS=1.45 PD=0.97
M$919 \$242 A1|PWDATA[3] \$260
+ LO|PRDATA[10]|PRDATA[12]|PRDATA[13]|PRDATA[15]|PRDATA[16]|PRDATA[17]|PRDATA[18]|PRDATA[19]|PRDATA[21]|PRDATA[23]|PRDATA[27]|PRDATA[28]|PRDATA[29]|PRDATA[31]|PRDATA[9]|PSLVERR|VGND
+ sky130_fd_pr__nfet_01v8 L=0.15 W=0.65 AS=0.104 AD=0.274625 PS=0.97 PD=1.495
M$920 \$260 S|X
+ LO|PRDATA[10]|PRDATA[12]|PRDATA[13]|PRDATA[15]|PRDATA[16]|PRDATA[17]|PRDATA[18]|PRDATA[19]|PRDATA[21]|PRDATA[23]|PRDATA[27]|PRDATA[28]|PRDATA[29]|PRDATA[31]|PRDATA[9]|PSLVERR|VGND
+ LO|PRDATA[10]|PRDATA[12]|PRDATA[13]|PRDATA[15]|PRDATA[16]|PRDATA[17]|PRDATA[18]|PRDATA[19]|PRDATA[21]|PRDATA[23]|PRDATA[27]|PRDATA[28]|PRDATA[29]|PRDATA[31]|PRDATA[9]|PSLVERR|VGND
+ sky130_fd_pr__nfet_01v8 L=0.15 W=0.65 AS=0.274625 AD=0.08775 PS=1.495 PD=0.92
M$921
+ LO|PRDATA[10]|PRDATA[12]|PRDATA[13]|PRDATA[15]|PRDATA[16]|PRDATA[17]|PRDATA[18]|PRDATA[19]|PRDATA[21]|PRDATA[23]|PRDATA[27]|PRDATA[28]|PRDATA[29]|PRDATA[31]|PRDATA[9]|PSLVERR|VGND
+ \$242 A|X
+ LO|PRDATA[10]|PRDATA[12]|PRDATA[13]|PRDATA[15]|PRDATA[16]|PRDATA[17]|PRDATA[18]|PRDATA[19]|PRDATA[21]|PRDATA[23]|PRDATA[27]|PRDATA[28]|PRDATA[29]|PRDATA[31]|PRDATA[9]|PSLVERR|VGND
+ sky130_fd_pr__nfet_01v8 L=0.15 W=2.6 AS=0.351 AD=0.43225 PS=3.68 PD=4.58
M$925
+ LO|PRDATA[10]|PRDATA[12]|PRDATA[13]|PRDATA[15]|PRDATA[16]|PRDATA[17]|PRDATA[18]|PRDATA[19]|PRDATA[21]|PRDATA[23]|PRDATA[27]|PRDATA[28]|PRDATA[29]|PRDATA[31]|PRDATA[9]|PSLVERR|VGND
+ A0|B2|Q|gpio_oe[3] \$253
+ LO|PRDATA[10]|PRDATA[12]|PRDATA[13]|PRDATA[15]|PRDATA[16]|PRDATA[17]|PRDATA[18]|PRDATA[19]|PRDATA[21]|PRDATA[23]|PRDATA[27]|PRDATA[28]|PRDATA[29]|PRDATA[31]|PRDATA[9]|PSLVERR|VGND
+ sky130_fd_pr__nfet_01v8 L=0.15 W=0.65 AS=0.169 AD=0.07475 PS=1.82 PD=0.88
M$926 \$253 B|B1|B_N|Y A2|Y
+ LO|PRDATA[10]|PRDATA[12]|PRDATA[13]|PRDATA[15]|PRDATA[16]|PRDATA[17]|PRDATA[18]|PRDATA[19]|PRDATA[21]|PRDATA[23]|PRDATA[27]|PRDATA[28]|PRDATA[29]|PRDATA[31]|PRDATA[9]|PSLVERR|VGND
+ sky130_fd_pr__nfet_01v8 L=0.15 W=0.65 AS=0.07475 AD=0.169 PS=0.88 PD=1.82
M$927 A2|Y A0|A1|Q|gpio_out[3] \$250
+ LO|PRDATA[10]|PRDATA[12]|PRDATA[13]|PRDATA[15]|PRDATA[16]|PRDATA[17]|PRDATA[18]|PRDATA[19]|PRDATA[21]|PRDATA[23]|PRDATA[27]|PRDATA[28]|PRDATA[29]|PRDATA[31]|PRDATA[9]|PSLVERR|VGND
+ sky130_fd_pr__nfet_01v8 L=0.15 W=0.65 AS=0.169 AD=0.06825 PS=1.82 PD=0.86
M$928 \$250 A2|B|C2|Y
+ LO|PRDATA[10]|PRDATA[12]|PRDATA[13]|PRDATA[15]|PRDATA[16]|PRDATA[17]|PRDATA[18]|PRDATA[19]|PRDATA[21]|PRDATA[23]|PRDATA[27]|PRDATA[28]|PRDATA[29]|PRDATA[31]|PRDATA[9]|PSLVERR|VGND
+ LO|PRDATA[10]|PRDATA[12]|PRDATA[13]|PRDATA[15]|PRDATA[16]|PRDATA[17]|PRDATA[18]|PRDATA[19]|PRDATA[21]|PRDATA[23]|PRDATA[27]|PRDATA[28]|PRDATA[29]|PRDATA[31]|PRDATA[9]|PSLVERR|VGND
+ sky130_fd_pr__nfet_01v8 L=0.15 W=0.65 AS=0.06825 AD=0.234 PS=0.86 PD=2.02
M$929 \$335 CLK|X
+ LO|PRDATA[10]|PRDATA[12]|PRDATA[13]|PRDATA[15]|PRDATA[16]|PRDATA[17]|PRDATA[18]|PRDATA[19]|PRDATA[21]|PRDATA[23]|PRDATA[27]|PRDATA[28]|PRDATA[29]|PRDATA[31]|PRDATA[9]|PSLVERR|VGND
+ LO|PRDATA[10]|PRDATA[12]|PRDATA[13]|PRDATA[15]|PRDATA[16]|PRDATA[17]|PRDATA[18]|PRDATA[19]|PRDATA[21]|PRDATA[23]|PRDATA[27]|PRDATA[28]|PRDATA[29]|PRDATA[31]|PRDATA[9]|PSLVERR|VGND
+ sky130_fd_pr__nfet_01v8 L=0.15 W=0.42 AS=0.1092 AD=0.0567 PS=1.36 PD=0.69
M$930
+ LO|PRDATA[10]|PRDATA[12]|PRDATA[13]|PRDATA[15]|PRDATA[16]|PRDATA[17]|PRDATA[18]|PRDATA[19]|PRDATA[21]|PRDATA[23]|PRDATA[27]|PRDATA[28]|PRDATA[29]|PRDATA[31]|PRDATA[9]|PSLVERR|VGND
+ \$335 \$336
+ LO|PRDATA[10]|PRDATA[12]|PRDATA[13]|PRDATA[15]|PRDATA[16]|PRDATA[17]|PRDATA[18]|PRDATA[19]|PRDATA[21]|PRDATA[23]|PRDATA[27]|PRDATA[28]|PRDATA[29]|PRDATA[31]|PRDATA[9]|PSLVERR|VGND
+ sky130_fd_pr__nfet_01v8 L=0.15 W=0.42 AS=0.0567 AD=0.1092 PS=0.69 PD=1.36
M$931
+ LO|PRDATA[10]|PRDATA[12]|PRDATA[13]|PRDATA[15]|PRDATA[16]|PRDATA[17]|PRDATA[18]|PRDATA[19]|PRDATA[21]|PRDATA[23]|PRDATA[27]|PRDATA[28]|PRDATA[29]|PRDATA[31]|PRDATA[9]|PSLVERR|VGND
+ D|X \$338
+ LO|PRDATA[10]|PRDATA[12]|PRDATA[13]|PRDATA[15]|PRDATA[16]|PRDATA[17]|PRDATA[18]|PRDATA[19]|PRDATA[21]|PRDATA[23]|PRDATA[27]|PRDATA[28]|PRDATA[29]|PRDATA[31]|PRDATA[9]|PSLVERR|VGND
+ sky130_fd_pr__nfet_01v8 L=0.15 W=0.42 AS=0.2205 AD=0.066 PS=1.89 PD=0.745
M$932 \$338 \$335 \$339
+ LO|PRDATA[10]|PRDATA[12]|PRDATA[13]|PRDATA[15]|PRDATA[16]|PRDATA[17]|PRDATA[18]|PRDATA[19]|PRDATA[21]|PRDATA[23]|PRDATA[27]|PRDATA[28]|PRDATA[29]|PRDATA[31]|PRDATA[9]|PSLVERR|VGND
+ sky130_fd_pr__nfet_01v8 L=0.15 W=0.36 AS=0.066 AD=0.0594 PS=0.745 PD=0.69
M$933 \$357 \$336 \$339
+ LO|PRDATA[10]|PRDATA[12]|PRDATA[13]|PRDATA[15]|PRDATA[16]|PRDATA[17]|PRDATA[18]|PRDATA[19]|PRDATA[21]|PRDATA[23]|PRDATA[27]|PRDATA[28]|PRDATA[29]|PRDATA[31]|PRDATA[9]|PSLVERR|VGND
+ sky130_fd_pr__nfet_01v8 L=0.15 W=0.36 AS=0.1401 AD=0.0594 PS=1.1 PD=0.69
M$934 \$357 \$341 \$356
+ LO|PRDATA[10]|PRDATA[12]|PRDATA[13]|PRDATA[15]|PRDATA[16]|PRDATA[17]|PRDATA[18]|PRDATA[19]|PRDATA[21]|PRDATA[23]|PRDATA[27]|PRDATA[28]|PRDATA[29]|PRDATA[31]|PRDATA[9]|PSLVERR|VGND
+ sky130_fd_pr__nfet_01v8 L=0.15 W=0.42 AS=0.1401 AD=0.0441 PS=1.1 PD=0.63
M$935
+ LO|PRDATA[10]|PRDATA[12]|PRDATA[13]|PRDATA[15]|PRDATA[16]|PRDATA[17]|PRDATA[18]|PRDATA[19]|PRDATA[21]|PRDATA[23]|PRDATA[27]|PRDATA[28]|PRDATA[29]|PRDATA[31]|PRDATA[9]|PSLVERR|VGND
+ PRESETn|RESET_B \$356
+ LO|PRDATA[10]|PRDATA[12]|PRDATA[13]|PRDATA[15]|PRDATA[16]|PRDATA[17]|PRDATA[18]|PRDATA[19]|PRDATA[21]|PRDATA[23]|PRDATA[27]|PRDATA[28]|PRDATA[29]|PRDATA[31]|PRDATA[9]|PSLVERR|VGND
+ sky130_fd_pr__nfet_01v8 L=0.15 W=0.42 AS=0.1346 AD=0.0441 PS=1.15 PD=0.63
M$936
+ LO|PRDATA[10]|PRDATA[12]|PRDATA[13]|PRDATA[15]|PRDATA[16]|PRDATA[17]|PRDATA[18]|PRDATA[19]|PRDATA[21]|PRDATA[23]|PRDATA[27]|PRDATA[28]|PRDATA[29]|PRDATA[31]|PRDATA[9]|PSLVERR|VGND
+ \$339 \$341
+ LO|PRDATA[10]|PRDATA[12]|PRDATA[13]|PRDATA[15]|PRDATA[16]|PRDATA[17]|PRDATA[18]|PRDATA[19]|PRDATA[21]|PRDATA[23]|PRDATA[27]|PRDATA[28]|PRDATA[29]|PRDATA[31]|PRDATA[9]|PSLVERR|VGND
+ sky130_fd_pr__nfet_01v8 L=0.15 W=0.64 AS=0.1346 AD=0.0999 PS=1.15 PD=0.985
M$937 \$341 \$336 \$342
+ LO|PRDATA[10]|PRDATA[12]|PRDATA[13]|PRDATA[15]|PRDATA[16]|PRDATA[17]|PRDATA[18]|PRDATA[19]|PRDATA[21]|PRDATA[23]|PRDATA[27]|PRDATA[28]|PRDATA[29]|PRDATA[31]|PRDATA[9]|PSLVERR|VGND
+ sky130_fd_pr__nfet_01v8 L=0.15 W=0.36 AS=0.0999 AD=0.0711 PS=0.985 PD=0.755
M$938 \$358 \$335 \$342
+ LO|PRDATA[10]|PRDATA[12]|PRDATA[13]|PRDATA[15]|PRDATA[16]|PRDATA[17]|PRDATA[18]|PRDATA[19]|PRDATA[21]|PRDATA[23]|PRDATA[27]|PRDATA[28]|PRDATA[29]|PRDATA[31]|PRDATA[9]|PSLVERR|VGND
+ sky130_fd_pr__nfet_01v8 L=0.15 W=0.36 AS=0.0669 AD=0.0711 PS=0.75 PD=0.755
M$939 \$358 \$343
+ LO|PRDATA[10]|PRDATA[12]|PRDATA[13]|PRDATA[15]|PRDATA[16]|PRDATA[17]|PRDATA[18]|PRDATA[19]|PRDATA[21]|PRDATA[23]|PRDATA[27]|PRDATA[28]|PRDATA[29]|PRDATA[31]|PRDATA[9]|PSLVERR|VGND
+ LO|PRDATA[10]|PRDATA[12]|PRDATA[13]|PRDATA[15]|PRDATA[16]|PRDATA[17]|PRDATA[18]|PRDATA[19]|PRDATA[21]|PRDATA[23]|PRDATA[27]|PRDATA[28]|PRDATA[29]|PRDATA[31]|PRDATA[9]|PSLVERR|VGND
+ sky130_fd_pr__nfet_01v8 L=0.15 W=0.42 AS=0.0669 AD=0.12495 PS=0.75 PD=1.015
M$940
+ LO|PRDATA[10]|PRDATA[12]|PRDATA[13]|PRDATA[15]|PRDATA[16]|PRDATA[17]|PRDATA[18]|PRDATA[19]|PRDATA[21]|PRDATA[23]|PRDATA[27]|PRDATA[28]|PRDATA[29]|PRDATA[31]|PRDATA[9]|PSLVERR|VGND
+ PRESETn|RESET_B \$359
+ LO|PRDATA[10]|PRDATA[12]|PRDATA[13]|PRDATA[15]|PRDATA[16]|PRDATA[17]|PRDATA[18]|PRDATA[19]|PRDATA[21]|PRDATA[23]|PRDATA[27]|PRDATA[28]|PRDATA[29]|PRDATA[31]|PRDATA[9]|PSLVERR|VGND
+ sky130_fd_pr__nfet_01v8 L=0.15 W=0.42 AS=0.12495 AD=0.06405 PS=1.015 PD=0.725
M$941 \$359 \$342 \$343
+ LO|PRDATA[10]|PRDATA[12]|PRDATA[13]|PRDATA[15]|PRDATA[16]|PRDATA[17]|PRDATA[18]|PRDATA[19]|PRDATA[21]|PRDATA[23]|PRDATA[27]|PRDATA[28]|PRDATA[29]|PRDATA[31]|PRDATA[9]|PSLVERR|VGND
+ sky130_fd_pr__nfet_01v8 L=0.15 W=0.42 AS=0.06405 AD=0.1092 PS=0.725 PD=1.36
M$942
+ LO|PRDATA[10]|PRDATA[12]|PRDATA[13]|PRDATA[15]|PRDATA[16]|PRDATA[17]|PRDATA[18]|PRDATA[19]|PRDATA[21]|PRDATA[23]|PRDATA[27]|PRDATA[28]|PRDATA[29]|PRDATA[31]|PRDATA[9]|PSLVERR|VGND
+ \$343 A0|B2|Q|gpio_oe[6]
+ LO|PRDATA[10]|PRDATA[12]|PRDATA[13]|PRDATA[15]|PRDATA[16]|PRDATA[17]|PRDATA[18]|PRDATA[19]|PRDATA[21]|PRDATA[23]|PRDATA[27]|PRDATA[28]|PRDATA[29]|PRDATA[31]|PRDATA[9]|PSLVERR|VGND
+ sky130_fd_pr__nfet_01v8 L=0.15 W=0.65 AS=0.2087 AD=0.169 PS=2.02 PD=1.82
M$943
+ LO|PRDATA[10]|PRDATA[12]|PRDATA[13]|PRDATA[15]|PRDATA[16]|PRDATA[17]|PRDATA[18]|PRDATA[19]|PRDATA[21]|PRDATA[23]|PRDATA[27]|PRDATA[28]|PRDATA[29]|PRDATA[31]|PRDATA[9]|PSLVERR|VGND
+ A|X \$344
+ LO|PRDATA[10]|PRDATA[12]|PRDATA[13]|PRDATA[15]|PRDATA[16]|PRDATA[17]|PRDATA[18]|PRDATA[19]|PRDATA[21]|PRDATA[23]|PRDATA[27]|PRDATA[28]|PRDATA[29]|PRDATA[31]|PRDATA[9]|PSLVERR|VGND
+ sky130_fd_pr__nfet_01v8 L=0.15 W=1.68 AS=0.2877 AD=0.2352 PS=3.47 PD=2.8
M$947
+ LO|PRDATA[10]|PRDATA[12]|PRDATA[13]|PRDATA[15]|PRDATA[16]|PRDATA[17]|PRDATA[18]|PRDATA[19]|PRDATA[21]|PRDATA[23]|PRDATA[27]|PRDATA[28]|PRDATA[29]|PRDATA[31]|PRDATA[9]|PSLVERR|VGND
+ \$344 CLK|X
+ LO|PRDATA[10]|PRDATA[12]|PRDATA[13]|PRDATA[15]|PRDATA[16]|PRDATA[17]|PRDATA[18]|PRDATA[19]|PRDATA[21]|PRDATA[23]|PRDATA[27]|PRDATA[28]|PRDATA[29]|PRDATA[31]|PRDATA[9]|PSLVERR|VGND
+ sky130_fd_pr__nfet_01v8 L=0.15 W=6.72 AS=0.93975 AD=0.99225 PS=11.195
+ PD=11.865
M$963 \$352 A1|gpio_in[3]
+ LO|PRDATA[10]|PRDATA[12]|PRDATA[13]|PRDATA[15]|PRDATA[16]|PRDATA[17]|PRDATA[18]|PRDATA[19]|PRDATA[21]|PRDATA[23]|PRDATA[27]|PRDATA[28]|PRDATA[29]|PRDATA[31]|PRDATA[9]|PSLVERR|VGND
+ LO|PRDATA[10]|PRDATA[12]|PRDATA[13]|PRDATA[15]|PRDATA[16]|PRDATA[17]|PRDATA[18]|PRDATA[19]|PRDATA[21]|PRDATA[23]|PRDATA[27]|PRDATA[28]|PRDATA[29]|PRDATA[31]|PRDATA[9]|PSLVERR|VGND
+ sky130_fd_pr__nfet_01v8 L=0.15 W=0.42 AS=0.1113 AD=0.0588 PS=1.37 PD=0.7
M$964
+ LO|PRDATA[10]|PRDATA[12]|PRDATA[13]|PRDATA[15]|PRDATA[16]|PRDATA[17]|PRDATA[18]|PRDATA[19]|PRDATA[21]|PRDATA[23]|PRDATA[27]|PRDATA[28]|PRDATA[29]|PRDATA[31]|PRDATA[9]|PSLVERR|VGND
+ A|A2|C|D_N|X \$352
+ LO|PRDATA[10]|PRDATA[12]|PRDATA[13]|PRDATA[15]|PRDATA[16]|PRDATA[17]|PRDATA[18]|PRDATA[19]|PRDATA[21]|PRDATA[23]|PRDATA[27]|PRDATA[28]|PRDATA[29]|PRDATA[31]|PRDATA[9]|PSLVERR|VGND
+ sky130_fd_pr__nfet_01v8 L=0.15 W=0.42 AS=0.0588 AD=0.0588 PS=0.7 PD=0.7
M$965 \$352 B|B1|Y A1|Y
+ LO|PRDATA[10]|PRDATA[12]|PRDATA[13]|PRDATA[15]|PRDATA[16]|PRDATA[17]|PRDATA[18]|PRDATA[19]|PRDATA[21]|PRDATA[23]|PRDATA[27]|PRDATA[28]|PRDATA[29]|PRDATA[31]|PRDATA[9]|PSLVERR|VGND
+ sky130_fd_pr__nfet_01v8 L=0.15 W=0.42 AS=0.0588 AD=0.1113 PS=0.7 PD=1.37
M$966
+ LO|PRDATA[10]|PRDATA[12]|PRDATA[13]|PRDATA[15]|PRDATA[16]|PRDATA[17]|PRDATA[18]|PRDATA[19]|PRDATA[21]|PRDATA[23]|PRDATA[27]|PRDATA[28]|PRDATA[29]|PRDATA[31]|PRDATA[9]|PSLVERR|VGND
+ A2|Y \$354
+ LO|PRDATA[10]|PRDATA[12]|PRDATA[13]|PRDATA[15]|PRDATA[16]|PRDATA[17]|PRDATA[18]|PRDATA[19]|PRDATA[21]|PRDATA[23]|PRDATA[27]|PRDATA[28]|PRDATA[29]|PRDATA[31]|PRDATA[9]|PSLVERR|VGND
+ sky130_fd_pr__nfet_01v8 L=0.15 W=0.65 AS=0.18525 AD=0.089375 PS=1.87 PD=0.925
M$967 \$354 A1|Y PRDATA[3]|Y
+ LO|PRDATA[10]|PRDATA[12]|PRDATA[13]|PRDATA[15]|PRDATA[16]|PRDATA[17]|PRDATA[18]|PRDATA[19]|PRDATA[21]|PRDATA[23]|PRDATA[27]|PRDATA[28]|PRDATA[29]|PRDATA[31]|PRDATA[9]|PSLVERR|VGND
+ sky130_fd_pr__nfet_01v8 L=0.15 W=0.65 AS=0.089375 AD=0.091 PS=0.925 PD=0.93
M$968 PRDATA[3]|Y A1|Y \$353
+ LO|PRDATA[10]|PRDATA[12]|PRDATA[13]|PRDATA[15]|PRDATA[16]|PRDATA[17]|PRDATA[18]|PRDATA[19]|PRDATA[21]|PRDATA[23]|PRDATA[27]|PRDATA[28]|PRDATA[29]|PRDATA[31]|PRDATA[9]|PSLVERR|VGND
+ sky130_fd_pr__nfet_01v8 L=0.15 W=0.65 AS=0.091 AD=0.06825 PS=0.93 PD=0.86
M$969 \$353 A2|Y
+ LO|PRDATA[10]|PRDATA[12]|PRDATA[13]|PRDATA[15]|PRDATA[16]|PRDATA[17]|PRDATA[18]|PRDATA[19]|PRDATA[21]|PRDATA[23]|PRDATA[27]|PRDATA[28]|PRDATA[29]|PRDATA[31]|PRDATA[9]|PSLVERR|VGND
+ LO|PRDATA[10]|PRDATA[12]|PRDATA[13]|PRDATA[15]|PRDATA[16]|PRDATA[17]|PRDATA[18]|PRDATA[19]|PRDATA[21]|PRDATA[23]|PRDATA[27]|PRDATA[28]|PRDATA[29]|PRDATA[31]|PRDATA[9]|PSLVERR|VGND
+ sky130_fd_pr__nfet_01v8 L=0.15 W=0.65 AS=0.06825 AD=0.10725 PS=0.86 PD=0.98
M$970
+ LO|PRDATA[10]|PRDATA[12]|PRDATA[13]|PRDATA[15]|PRDATA[16]|PRDATA[17]|PRDATA[18]|PRDATA[19]|PRDATA[21]|PRDATA[23]|PRDATA[27]|PRDATA[28]|PRDATA[29]|PRDATA[31]|PRDATA[9]|PSLVERR|VGND
+ A|B1|X PRDATA[3]|Y
+ LO|PRDATA[10]|PRDATA[12]|PRDATA[13]|PRDATA[15]|PRDATA[16]|PRDATA[17]|PRDATA[18]|PRDATA[19]|PRDATA[21]|PRDATA[23]|PRDATA[27]|PRDATA[28]|PRDATA[29]|PRDATA[31]|PRDATA[9]|PSLVERR|VGND
+ sky130_fd_pr__nfet_01v8 L=0.15 W=1.3 AS=0.195 AD=0.34775 PS=1.9 PD=3.02
M$972
+ LO|PRDATA[10]|PRDATA[12]|PRDATA[13]|PRDATA[15]|PRDATA[16]|PRDATA[17]|PRDATA[18]|PRDATA[19]|PRDATA[21]|PRDATA[23]|PRDATA[27]|PRDATA[28]|PRDATA[29]|PRDATA[31]|PRDATA[9]|PSLVERR|VGND
+ A|X \$360
+ LO|PRDATA[10]|PRDATA[12]|PRDATA[13]|PRDATA[15]|PRDATA[16]|PRDATA[17]|PRDATA[18]|PRDATA[19]|PRDATA[21]|PRDATA[23]|PRDATA[27]|PRDATA[28]|PRDATA[29]|PRDATA[31]|PRDATA[9]|PSLVERR|VGND
+ sky130_fd_pr__nfet_01v8 L=0.15 W=1.3 AS=0.25675 AD=0.1755 PS=2.74 PD=1.84
M$974
+ LO|PRDATA[10]|PRDATA[12]|PRDATA[13]|PRDATA[15]|PRDATA[16]|PRDATA[17]|PRDATA[18]|PRDATA[19]|PRDATA[21]|PRDATA[23]|PRDATA[27]|PRDATA[28]|PRDATA[29]|PRDATA[31]|PRDATA[9]|PSLVERR|VGND
+ \$360 D|X
+ LO|PRDATA[10]|PRDATA[12]|PRDATA[13]|PRDATA[15]|PRDATA[16]|PRDATA[17]|PRDATA[18]|PRDATA[19]|PRDATA[21]|PRDATA[23]|PRDATA[27]|PRDATA[28]|PRDATA[29]|PRDATA[31]|PRDATA[9]|PSLVERR|VGND
+ sky130_fd_pr__nfet_01v8 L=0.15 W=3.9 AS=0.5265 AD=0.60775 PS=5.52 PD=6.42
M$980 \$362 CLK|X
+ LO|PRDATA[10]|PRDATA[12]|PRDATA[13]|PRDATA[15]|PRDATA[16]|PRDATA[17]|PRDATA[18]|PRDATA[19]|PRDATA[21]|PRDATA[23]|PRDATA[27]|PRDATA[28]|PRDATA[29]|PRDATA[31]|PRDATA[9]|PSLVERR|VGND
+ LO|PRDATA[10]|PRDATA[12]|PRDATA[13]|PRDATA[15]|PRDATA[16]|PRDATA[17]|PRDATA[18]|PRDATA[19]|PRDATA[21]|PRDATA[23]|PRDATA[27]|PRDATA[28]|PRDATA[29]|PRDATA[31]|PRDATA[9]|PSLVERR|VGND
+ sky130_fd_pr__nfet_01v8 L=0.15 W=0.42 AS=0.1092 AD=0.0567 PS=1.36 PD=0.69
M$981
+ LO|PRDATA[10]|PRDATA[12]|PRDATA[13]|PRDATA[15]|PRDATA[16]|PRDATA[17]|PRDATA[18]|PRDATA[19]|PRDATA[21]|PRDATA[23]|PRDATA[27]|PRDATA[28]|PRDATA[29]|PRDATA[31]|PRDATA[9]|PSLVERR|VGND
+ \$362 \$363
+ LO|PRDATA[10]|PRDATA[12]|PRDATA[13]|PRDATA[15]|PRDATA[16]|PRDATA[17]|PRDATA[18]|PRDATA[19]|PRDATA[21]|PRDATA[23]|PRDATA[27]|PRDATA[28]|PRDATA[29]|PRDATA[31]|PRDATA[9]|PSLVERR|VGND
+ sky130_fd_pr__nfet_01v8 L=0.15 W=0.42 AS=0.0567 AD=0.1092 PS=0.69 PD=1.36
M$982 \$364 \$362 \$365
+ LO|PRDATA[10]|PRDATA[12]|PRDATA[13]|PRDATA[15]|PRDATA[16]|PRDATA[17]|PRDATA[18]|PRDATA[19]|PRDATA[21]|PRDATA[23]|PRDATA[27]|PRDATA[28]|PRDATA[29]|PRDATA[31]|PRDATA[9]|PSLVERR|VGND
+ sky130_fd_pr__nfet_01v8 L=0.15 W=0.36 AS=0.066 AD=0.0594 PS=0.745 PD=0.69
M$983 \$365 \$363 \$386
+ LO|PRDATA[10]|PRDATA[12]|PRDATA[13]|PRDATA[15]|PRDATA[16]|PRDATA[17]|PRDATA[18]|PRDATA[19]|PRDATA[21]|PRDATA[23]|PRDATA[27]|PRDATA[28]|PRDATA[29]|PRDATA[31]|PRDATA[9]|PSLVERR|VGND
+ sky130_fd_pr__nfet_01v8 L=0.15 W=0.36 AS=0.0594 AD=0.1401 PS=0.69 PD=1.1
M$984 \$425 \$363 \$366
+ LO|PRDATA[10]|PRDATA[12]|PRDATA[13]|PRDATA[15]|PRDATA[16]|PRDATA[17]|PRDATA[18]|PRDATA[19]|PRDATA[21]|PRDATA[23]|PRDATA[27]|PRDATA[28]|PRDATA[29]|PRDATA[31]|PRDATA[9]|PSLVERR|VGND
+ sky130_fd_pr__nfet_01v8 L=0.15 W=0.36 AS=0.0999 AD=0.0711 PS=0.985 PD=0.755
M$985 \$366 \$362 \$387
+ LO|PRDATA[10]|PRDATA[12]|PRDATA[13]|PRDATA[15]|PRDATA[16]|PRDATA[17]|PRDATA[18]|PRDATA[19]|PRDATA[21]|PRDATA[23]|PRDATA[27]|PRDATA[28]|PRDATA[29]|PRDATA[31]|PRDATA[9]|PSLVERR|VGND
+ sky130_fd_pr__nfet_01v8 L=0.15 W=0.36 AS=0.0711 AD=0.0669 PS=0.755 PD=0.75
M$986
+ LO|PRDATA[10]|PRDATA[12]|PRDATA[13]|PRDATA[15]|PRDATA[16]|PRDATA[17]|PRDATA[18]|PRDATA[19]|PRDATA[21]|PRDATA[23]|PRDATA[27]|PRDATA[28]|PRDATA[29]|PRDATA[31]|PRDATA[9]|PSLVERR|VGND
+ D|X \$364
+ LO|PRDATA[10]|PRDATA[12]|PRDATA[13]|PRDATA[15]|PRDATA[16]|PRDATA[17]|PRDATA[18]|PRDATA[19]|PRDATA[21]|PRDATA[23]|PRDATA[27]|PRDATA[28]|PRDATA[29]|PRDATA[31]|PRDATA[9]|PSLVERR|VGND
+ sky130_fd_pr__nfet_01v8 L=0.15 W=0.42 AS=0.2205 AD=0.066 PS=1.89 PD=0.745
M$987 \$386 \$425 \$385
+ LO|PRDATA[10]|PRDATA[12]|PRDATA[13]|PRDATA[15]|PRDATA[16]|PRDATA[17]|PRDATA[18]|PRDATA[19]|PRDATA[21]|PRDATA[23]|PRDATA[27]|PRDATA[28]|PRDATA[29]|PRDATA[31]|PRDATA[9]|PSLVERR|VGND
+ sky130_fd_pr__nfet_01v8 L=0.15 W=0.42 AS=0.1401 AD=0.0441 PS=1.1 PD=0.63
M$988 \$385 PRESETn|RESET_B
+ LO|PRDATA[10]|PRDATA[12]|PRDATA[13]|PRDATA[15]|PRDATA[16]|PRDATA[17]|PRDATA[18]|PRDATA[19]|PRDATA[21]|PRDATA[23]|PRDATA[27]|PRDATA[28]|PRDATA[29]|PRDATA[31]|PRDATA[9]|PSLVERR|VGND
+ LO|PRDATA[10]|PRDATA[12]|PRDATA[13]|PRDATA[15]|PRDATA[16]|PRDATA[17]|PRDATA[18]|PRDATA[19]|PRDATA[21]|PRDATA[23]|PRDATA[27]|PRDATA[28]|PRDATA[29]|PRDATA[31]|PRDATA[9]|PSLVERR|VGND
+ sky130_fd_pr__nfet_01v8 L=0.15 W=0.42 AS=0.0441 AD=0.1346 PS=0.63 PD=1.15
M$989 \$387 \$367
+ LO|PRDATA[10]|PRDATA[12]|PRDATA[13]|PRDATA[15]|PRDATA[16]|PRDATA[17]|PRDATA[18]|PRDATA[19]|PRDATA[21]|PRDATA[23]|PRDATA[27]|PRDATA[28]|PRDATA[29]|PRDATA[31]|PRDATA[9]|PSLVERR|VGND
+ LO|PRDATA[10]|PRDATA[12]|PRDATA[13]|PRDATA[15]|PRDATA[16]|PRDATA[17]|PRDATA[18]|PRDATA[19]|PRDATA[21]|PRDATA[23]|PRDATA[27]|PRDATA[28]|PRDATA[29]|PRDATA[31]|PRDATA[9]|PSLVERR|VGND
+ sky130_fd_pr__nfet_01v8 L=0.15 W=0.42 AS=0.0669 AD=0.12495 PS=0.75 PD=1.015
M$990
+ LO|PRDATA[10]|PRDATA[12]|PRDATA[13]|PRDATA[15]|PRDATA[16]|PRDATA[17]|PRDATA[18]|PRDATA[19]|PRDATA[21]|PRDATA[23]|PRDATA[27]|PRDATA[28]|PRDATA[29]|PRDATA[31]|PRDATA[9]|PSLVERR|VGND
+ PRESETn|RESET_B \$389
+ LO|PRDATA[10]|PRDATA[12]|PRDATA[13]|PRDATA[15]|PRDATA[16]|PRDATA[17]|PRDATA[18]|PRDATA[19]|PRDATA[21]|PRDATA[23]|PRDATA[27]|PRDATA[28]|PRDATA[29]|PRDATA[31]|PRDATA[9]|PSLVERR|VGND
+ sky130_fd_pr__nfet_01v8 L=0.15 W=0.42 AS=0.12495 AD=0.06405 PS=1.015 PD=0.725
M$991 \$389 \$366 \$367
+ LO|PRDATA[10]|PRDATA[12]|PRDATA[13]|PRDATA[15]|PRDATA[16]|PRDATA[17]|PRDATA[18]|PRDATA[19]|PRDATA[21]|PRDATA[23]|PRDATA[27]|PRDATA[28]|PRDATA[29]|PRDATA[31]|PRDATA[9]|PSLVERR|VGND
+ sky130_fd_pr__nfet_01v8 L=0.15 W=0.42 AS=0.06405 AD=0.1092 PS=0.725 PD=1.36
M$992
+ LO|PRDATA[10]|PRDATA[12]|PRDATA[13]|PRDATA[15]|PRDATA[16]|PRDATA[17]|PRDATA[18]|PRDATA[19]|PRDATA[21]|PRDATA[23]|PRDATA[27]|PRDATA[28]|PRDATA[29]|PRDATA[31]|PRDATA[9]|PSLVERR|VGND
+ \$365 \$425
+ LO|PRDATA[10]|PRDATA[12]|PRDATA[13]|PRDATA[15]|PRDATA[16]|PRDATA[17]|PRDATA[18]|PRDATA[19]|PRDATA[21]|PRDATA[23]|PRDATA[27]|PRDATA[28]|PRDATA[29]|PRDATA[31]|PRDATA[9]|PSLVERR|VGND
+ sky130_fd_pr__nfet_01v8 L=0.15 W=0.64 AS=0.1346 AD=0.0999 PS=1.15 PD=0.985
M$993
+ LO|PRDATA[10]|PRDATA[12]|PRDATA[13]|PRDATA[15]|PRDATA[16]|PRDATA[17]|PRDATA[18]|PRDATA[19]|PRDATA[21]|PRDATA[23]|PRDATA[27]|PRDATA[28]|PRDATA[29]|PRDATA[31]|PRDATA[9]|PSLVERR|VGND
+ \$367 A0|A1|Q|gpio_out[6]
+ LO|PRDATA[10]|PRDATA[12]|PRDATA[13]|PRDATA[15]|PRDATA[16]|PRDATA[17]|PRDATA[18]|PRDATA[19]|PRDATA[21]|PRDATA[23]|PRDATA[27]|PRDATA[28]|PRDATA[29]|PRDATA[31]|PRDATA[9]|PSLVERR|VGND
+ sky130_fd_pr__nfet_01v8 L=0.15 W=0.65 AS=0.2087 AD=0.169 PS=2.02 PD=1.82
M$994
+ LO|PRDATA[10]|PRDATA[12]|PRDATA[13]|PRDATA[15]|PRDATA[16]|PRDATA[17]|PRDATA[18]|PRDATA[19]|PRDATA[21]|PRDATA[23]|PRDATA[27]|PRDATA[28]|PRDATA[29]|PRDATA[31]|PRDATA[9]|PSLVERR|VGND
+ A0|B2|Q|gpio_oe[6] \$394
+ LO|PRDATA[10]|PRDATA[12]|PRDATA[13]|PRDATA[15]|PRDATA[16]|PRDATA[17]|PRDATA[18]|PRDATA[19]|PRDATA[21]|PRDATA[23]|PRDATA[27]|PRDATA[28]|PRDATA[29]|PRDATA[31]|PRDATA[9]|PSLVERR|VGND
+ sky130_fd_pr__nfet_01v8 L=0.15 W=0.65 AS=0.169 AD=0.07475 PS=1.82 PD=0.88
M$995 \$394 B|B1|B_N|Y A2|Y
+ LO|PRDATA[10]|PRDATA[12]|PRDATA[13]|PRDATA[15]|PRDATA[16]|PRDATA[17]|PRDATA[18]|PRDATA[19]|PRDATA[21]|PRDATA[23]|PRDATA[27]|PRDATA[28]|PRDATA[29]|PRDATA[31]|PRDATA[9]|PSLVERR|VGND
+ sky130_fd_pr__nfet_01v8 L=0.15 W=0.65 AS=0.07475 AD=0.169 PS=0.88 PD=1.82
M$996 A2|Y A0|A1|Q|gpio_out[6] \$396
+ LO|PRDATA[10]|PRDATA[12]|PRDATA[13]|PRDATA[15]|PRDATA[16]|PRDATA[17]|PRDATA[18]|PRDATA[19]|PRDATA[21]|PRDATA[23]|PRDATA[27]|PRDATA[28]|PRDATA[29]|PRDATA[31]|PRDATA[9]|PSLVERR|VGND
+ sky130_fd_pr__nfet_01v8 L=0.15 W=0.65 AS=0.169 AD=0.06825 PS=1.82 PD=0.86
M$997 \$396 A2|B|C2|Y
+ LO|PRDATA[10]|PRDATA[12]|PRDATA[13]|PRDATA[15]|PRDATA[16]|PRDATA[17]|PRDATA[18]|PRDATA[19]|PRDATA[21]|PRDATA[23]|PRDATA[27]|PRDATA[28]|PRDATA[29]|PRDATA[31]|PRDATA[9]|PSLVERR|VGND
+ LO|PRDATA[10]|PRDATA[12]|PRDATA[13]|PRDATA[15]|PRDATA[16]|PRDATA[17]|PRDATA[18]|PRDATA[19]|PRDATA[21]|PRDATA[23]|PRDATA[27]|PRDATA[28]|PRDATA[29]|PRDATA[31]|PRDATA[9]|PSLVERR|VGND
+ sky130_fd_pr__nfet_01v8 L=0.15 W=0.65 AS=0.06825 AD=0.234 PS=0.86 PD=2.02
M$998 \$369 S|X
+ LO|PRDATA[10]|PRDATA[12]|PRDATA[13]|PRDATA[15]|PRDATA[16]|PRDATA[17]|PRDATA[18]|PRDATA[19]|PRDATA[21]|PRDATA[23]|PRDATA[27]|PRDATA[28]|PRDATA[29]|PRDATA[31]|PRDATA[9]|PSLVERR|VGND
+ LO|PRDATA[10]|PRDATA[12]|PRDATA[13]|PRDATA[15]|PRDATA[16]|PRDATA[17]|PRDATA[18]|PRDATA[19]|PRDATA[21]|PRDATA[23]|PRDATA[27]|PRDATA[28]|PRDATA[29]|PRDATA[31]|PRDATA[9]|PSLVERR|VGND
+ sky130_fd_pr__nfet_01v8 L=0.15 W=0.65 AS=0.169 AD=0.108875 PS=1.82 PD=0.985
M$999
+ LO|PRDATA[10]|PRDATA[12]|PRDATA[13]|PRDATA[15]|PRDATA[16]|PRDATA[17]|PRDATA[18]|PRDATA[19]|PRDATA[21]|PRDATA[23]|PRDATA[27]|PRDATA[28]|PRDATA[29]|PRDATA[31]|PRDATA[9]|PSLVERR|VGND
+ \$369 \$404
+ LO|PRDATA[10]|PRDATA[12]|PRDATA[13]|PRDATA[15]|PRDATA[16]|PRDATA[17]|PRDATA[18]|PRDATA[19]|PRDATA[21]|PRDATA[23]|PRDATA[27]|PRDATA[28]|PRDATA[29]|PRDATA[31]|PRDATA[9]|PSLVERR|VGND
+ sky130_fd_pr__nfet_01v8 L=0.15 W=0.65 AS=0.108875 AD=0.26 PS=0.985 PD=1.45
M$1000 \$404 A0|A1|Q|gpio_out[1] \$370
+ LO|PRDATA[10]|PRDATA[12]|PRDATA[13]|PRDATA[15]|PRDATA[16]|PRDATA[17]|PRDATA[18]|PRDATA[19]|PRDATA[21]|PRDATA[23]|PRDATA[27]|PRDATA[28]|PRDATA[29]|PRDATA[31]|PRDATA[9]|PSLVERR|VGND
+ sky130_fd_pr__nfet_01v8 L=0.15 W=0.65 AS=0.26 AD=0.104 PS=1.45 PD=0.97
M$1001 \$370 A1|PWDATA[1] \$406
+ LO|PRDATA[10]|PRDATA[12]|PRDATA[13]|PRDATA[15]|PRDATA[16]|PRDATA[17]|PRDATA[18]|PRDATA[19]|PRDATA[21]|PRDATA[23]|PRDATA[27]|PRDATA[28]|PRDATA[29]|PRDATA[31]|PRDATA[9]|PSLVERR|VGND
+ sky130_fd_pr__nfet_01v8 L=0.15 W=0.65 AS=0.104 AD=0.274625 PS=0.97 PD=1.495
M$1002 \$406 S|X
+ LO|PRDATA[10]|PRDATA[12]|PRDATA[13]|PRDATA[15]|PRDATA[16]|PRDATA[17]|PRDATA[18]|PRDATA[19]|PRDATA[21]|PRDATA[23]|PRDATA[27]|PRDATA[28]|PRDATA[29]|PRDATA[31]|PRDATA[9]|PSLVERR|VGND
+ LO|PRDATA[10]|PRDATA[12]|PRDATA[13]|PRDATA[15]|PRDATA[16]|PRDATA[17]|PRDATA[18]|PRDATA[19]|PRDATA[21]|PRDATA[23]|PRDATA[27]|PRDATA[28]|PRDATA[29]|PRDATA[31]|PRDATA[9]|PSLVERR|VGND
+ sky130_fd_pr__nfet_01v8 L=0.15 W=0.65 AS=0.274625 AD=0.08775 PS=1.495 PD=0.92
M$1003
+ LO|PRDATA[10]|PRDATA[12]|PRDATA[13]|PRDATA[15]|PRDATA[16]|PRDATA[17]|PRDATA[18]|PRDATA[19]|PRDATA[21]|PRDATA[23]|PRDATA[27]|PRDATA[28]|PRDATA[29]|PRDATA[31]|PRDATA[9]|PSLVERR|VGND
+ \$370 A|X
+ LO|PRDATA[10]|PRDATA[12]|PRDATA[13]|PRDATA[15]|PRDATA[16]|PRDATA[17]|PRDATA[18]|PRDATA[19]|PRDATA[21]|PRDATA[23]|PRDATA[27]|PRDATA[28]|PRDATA[29]|PRDATA[31]|PRDATA[9]|PSLVERR|VGND
+ sky130_fd_pr__nfet_01v8 L=0.15 W=2.6 AS=0.351 AD=0.43225 PS=3.68 PD=4.58
M$1007
+ LO|PRDATA[10]|PRDATA[12]|PRDATA[13]|PRDATA[15]|PRDATA[16]|PRDATA[17]|PRDATA[18]|PRDATA[19]|PRDATA[21]|PRDATA[23]|PRDATA[27]|PRDATA[28]|PRDATA[29]|PRDATA[31]|PRDATA[9]|PSLVERR|VGND
+ A|X \$372
+ LO|PRDATA[10]|PRDATA[12]|PRDATA[13]|PRDATA[15]|PRDATA[16]|PRDATA[17]|PRDATA[18]|PRDATA[19]|PRDATA[21]|PRDATA[23]|PRDATA[27]|PRDATA[28]|PRDATA[29]|PRDATA[31]|PRDATA[9]|PSLVERR|VGND
+ sky130_fd_pr__nfet_01v8 L=0.15 W=1.3 AS=0.25675 AD=0.1755 PS=2.74 PD=1.84
M$1009
+ LO|PRDATA[10]|PRDATA[12]|PRDATA[13]|PRDATA[15]|PRDATA[16]|PRDATA[17]|PRDATA[18]|PRDATA[19]|PRDATA[21]|PRDATA[23]|PRDATA[27]|PRDATA[28]|PRDATA[29]|PRDATA[31]|PRDATA[9]|PSLVERR|VGND
+ \$372 D|X
+ LO|PRDATA[10]|PRDATA[12]|PRDATA[13]|PRDATA[15]|PRDATA[16]|PRDATA[17]|PRDATA[18]|PRDATA[19]|PRDATA[21]|PRDATA[23]|PRDATA[27]|PRDATA[28]|PRDATA[29]|PRDATA[31]|PRDATA[9]|PSLVERR|VGND
+ sky130_fd_pr__nfet_01v8 L=0.15 W=3.9 AS=0.5265 AD=0.60775 PS=5.52 PD=6.42
M$1015 \$373 A|Y
+ LO|PRDATA[10]|PRDATA[12]|PRDATA[13]|PRDATA[15]|PRDATA[16]|PRDATA[17]|PRDATA[18]|PRDATA[19]|PRDATA[21]|PRDATA[23]|PRDATA[27]|PRDATA[28]|PRDATA[29]|PRDATA[31]|PRDATA[9]|PSLVERR|VGND
+ LO|PRDATA[10]|PRDATA[12]|PRDATA[13]|PRDATA[15]|PRDATA[16]|PRDATA[17]|PRDATA[18]|PRDATA[19]|PRDATA[21]|PRDATA[23]|PRDATA[27]|PRDATA[28]|PRDATA[29]|PRDATA[31]|PRDATA[9]|PSLVERR|VGND
+ sky130_fd_pr__nfet_01v8 L=0.15 W=0.65 AS=0.169 AD=0.08775 PS=1.82 PD=0.92
M$1016
+ LO|PRDATA[10]|PRDATA[12]|PRDATA[13]|PRDATA[15]|PRDATA[16]|PRDATA[17]|PRDATA[18]|PRDATA[19]|PRDATA[21]|PRDATA[23]|PRDATA[27]|PRDATA[28]|PRDATA[29]|PRDATA[31]|PRDATA[9]|PSLVERR|VGND
+ \$373 S|X
+ LO|PRDATA[10]|PRDATA[12]|PRDATA[13]|PRDATA[15]|PRDATA[16]|PRDATA[17]|PRDATA[18]|PRDATA[19]|PRDATA[21]|PRDATA[23]|PRDATA[27]|PRDATA[28]|PRDATA[29]|PRDATA[31]|PRDATA[9]|PSLVERR|VGND
+ sky130_fd_pr__nfet_01v8 L=0.15 W=2.6 AS=0.351 AD=0.43225 PS=3.68 PD=4.58
M$1020 \$374 A|X
+ LO|PRDATA[10]|PRDATA[12]|PRDATA[13]|PRDATA[15]|PRDATA[16]|PRDATA[17]|PRDATA[18]|PRDATA[19]|PRDATA[21]|PRDATA[23]|PRDATA[27]|PRDATA[28]|PRDATA[29]|PRDATA[31]|PRDATA[9]|PSLVERR|VGND
+ LO|PRDATA[10]|PRDATA[12]|PRDATA[13]|PRDATA[15]|PRDATA[16]|PRDATA[17]|PRDATA[18]|PRDATA[19]|PRDATA[21]|PRDATA[23]|PRDATA[27]|PRDATA[28]|PRDATA[29]|PRDATA[31]|PRDATA[9]|PSLVERR|VGND
+ sky130_fd_pr__nfet_01v8 L=0.15 W=0.42 AS=0.1092 AD=0.097 PS=1.36 PD=0.975
M$1021
+ LO|PRDATA[10]|PRDATA[12]|PRDATA[13]|PRDATA[15]|PRDATA[16]|PRDATA[17]|PRDATA[18]|PRDATA[19]|PRDATA[21]|PRDATA[23]|PRDATA[27]|PRDATA[28]|PRDATA[29]|PRDATA[31]|PRDATA[9]|PSLVERR|VGND
+ \$374 B|PREADY|X
+ LO|PRDATA[10]|PRDATA[12]|PRDATA[13]|PRDATA[15]|PRDATA[16]|PRDATA[17]|PRDATA[18]|PRDATA[19]|PRDATA[21]|PRDATA[23]|PRDATA[27]|PRDATA[28]|PRDATA[29]|PRDATA[31]|PRDATA[9]|PSLVERR|VGND
+ sky130_fd_pr__nfet_01v8 L=0.15 W=1.3 AS=0.18475 AD=0.26 PS=1.895 PD=2.75
M$1023 \$434 S|X
+ LO|PRDATA[10]|PRDATA[12]|PRDATA[13]|PRDATA[15]|PRDATA[16]|PRDATA[17]|PRDATA[18]|PRDATA[19]|PRDATA[21]|PRDATA[23]|PRDATA[27]|PRDATA[28]|PRDATA[29]|PRDATA[31]|PRDATA[9]|PSLVERR|VGND
+ LO|PRDATA[10]|PRDATA[12]|PRDATA[13]|PRDATA[15]|PRDATA[16]|PRDATA[17]|PRDATA[18]|PRDATA[19]|PRDATA[21]|PRDATA[23]|PRDATA[27]|PRDATA[28]|PRDATA[29]|PRDATA[31]|PRDATA[9]|PSLVERR|VGND
+ sky130_fd_pr__nfet_01v8 L=0.15 W=0.65 AS=0.169 AD=0.108875 PS=1.82 PD=0.985
M$1024
+ LO|PRDATA[10]|PRDATA[12]|PRDATA[13]|PRDATA[15]|PRDATA[16]|PRDATA[17]|PRDATA[18]|PRDATA[19]|PRDATA[21]|PRDATA[23]|PRDATA[27]|PRDATA[28]|PRDATA[29]|PRDATA[31]|PRDATA[9]|PSLVERR|VGND
+ \$434 \$454
+ LO|PRDATA[10]|PRDATA[12]|PRDATA[13]|PRDATA[15]|PRDATA[16]|PRDATA[17]|PRDATA[18]|PRDATA[19]|PRDATA[21]|PRDATA[23]|PRDATA[27]|PRDATA[28]|PRDATA[29]|PRDATA[31]|PRDATA[9]|PSLVERR|VGND
+ sky130_fd_pr__nfet_01v8 L=0.15 W=0.65 AS=0.108875 AD=0.26 PS=0.985 PD=1.45
M$1025 \$454 A0|A1|Q|gpio_out[6] \$437
+ LO|PRDATA[10]|PRDATA[12]|PRDATA[13]|PRDATA[15]|PRDATA[16]|PRDATA[17]|PRDATA[18]|PRDATA[19]|PRDATA[21]|PRDATA[23]|PRDATA[27]|PRDATA[28]|PRDATA[29]|PRDATA[31]|PRDATA[9]|PSLVERR|VGND
+ sky130_fd_pr__nfet_01v8 L=0.15 W=0.65 AS=0.26 AD=0.104 PS=1.45 PD=0.97
M$1026 \$437 A1|PWDATA[6] \$455
+ LO|PRDATA[10]|PRDATA[12]|PRDATA[13]|PRDATA[15]|PRDATA[16]|PRDATA[17]|PRDATA[18]|PRDATA[19]|PRDATA[21]|PRDATA[23]|PRDATA[27]|PRDATA[28]|PRDATA[29]|PRDATA[31]|PRDATA[9]|PSLVERR|VGND
+ sky130_fd_pr__nfet_01v8 L=0.15 W=0.65 AS=0.104 AD=0.274625 PS=0.97 PD=1.495
M$1027 \$455 S|X
+ LO|PRDATA[10]|PRDATA[12]|PRDATA[13]|PRDATA[15]|PRDATA[16]|PRDATA[17]|PRDATA[18]|PRDATA[19]|PRDATA[21]|PRDATA[23]|PRDATA[27]|PRDATA[28]|PRDATA[29]|PRDATA[31]|PRDATA[9]|PSLVERR|VGND
+ LO|PRDATA[10]|PRDATA[12]|PRDATA[13]|PRDATA[15]|PRDATA[16]|PRDATA[17]|PRDATA[18]|PRDATA[19]|PRDATA[21]|PRDATA[23]|PRDATA[27]|PRDATA[28]|PRDATA[29]|PRDATA[31]|PRDATA[9]|PSLVERR|VGND
+ sky130_fd_pr__nfet_01v8 L=0.15 W=0.65 AS=0.274625 AD=0.08775 PS=1.495 PD=0.92
M$1028
+ LO|PRDATA[10]|PRDATA[12]|PRDATA[13]|PRDATA[15]|PRDATA[16]|PRDATA[17]|PRDATA[18]|PRDATA[19]|PRDATA[21]|PRDATA[23]|PRDATA[27]|PRDATA[28]|PRDATA[29]|PRDATA[31]|PRDATA[9]|PSLVERR|VGND
+ \$437 A|X
+ LO|PRDATA[10]|PRDATA[12]|PRDATA[13]|PRDATA[15]|PRDATA[16]|PRDATA[17]|PRDATA[18]|PRDATA[19]|PRDATA[21]|PRDATA[23]|PRDATA[27]|PRDATA[28]|PRDATA[29]|PRDATA[31]|PRDATA[9]|PSLVERR|VGND
+ sky130_fd_pr__nfet_01v8 L=0.15 W=2.6 AS=0.351 AD=0.43225 PS=3.68 PD=4.58
M$1032 \$457 A|X
+ LO|PRDATA[10]|PRDATA[12]|PRDATA[13]|PRDATA[15]|PRDATA[16]|PRDATA[17]|PRDATA[18]|PRDATA[19]|PRDATA[21]|PRDATA[23]|PRDATA[27]|PRDATA[28]|PRDATA[29]|PRDATA[31]|PRDATA[9]|PSLVERR|VGND
+ LO|PRDATA[10]|PRDATA[12]|PRDATA[13]|PRDATA[15]|PRDATA[16]|PRDATA[17]|PRDATA[18]|PRDATA[19]|PRDATA[21]|PRDATA[23]|PRDATA[27]|PRDATA[28]|PRDATA[29]|PRDATA[31]|PRDATA[9]|PSLVERR|VGND
+ sky130_fd_pr__nfet_01v8 L=0.15 W=0.65 AS=0.169 AD=0.08775 PS=1.82 PD=0.92
M$1033
+ LO|PRDATA[10]|PRDATA[12]|PRDATA[13]|PRDATA[15]|PRDATA[16]|PRDATA[17]|PRDATA[18]|PRDATA[19]|PRDATA[21]|PRDATA[23]|PRDATA[27]|PRDATA[28]|PRDATA[29]|PRDATA[31]|PRDATA[9]|PSLVERR|VGND
+ \$457 D|X
+ LO|PRDATA[10]|PRDATA[12]|PRDATA[13]|PRDATA[15]|PRDATA[16]|PRDATA[17]|PRDATA[18]|PRDATA[19]|PRDATA[21]|PRDATA[23]|PRDATA[27]|PRDATA[28]|PRDATA[29]|PRDATA[31]|PRDATA[9]|PSLVERR|VGND
+ sky130_fd_pr__nfet_01v8 L=0.15 W=2.6 AS=0.351 AD=0.43225 PS=3.68 PD=4.58
M$1037
+ LO|PRDATA[10]|PRDATA[12]|PRDATA[13]|PRDATA[15]|PRDATA[16]|PRDATA[17]|PRDATA[18]|PRDATA[19]|PRDATA[21]|PRDATA[23]|PRDATA[27]|PRDATA[28]|PRDATA[29]|PRDATA[31]|PRDATA[9]|PSLVERR|VGND
+ A0|B2|Q|gpio_oe[2] \$526
+ LO|PRDATA[10]|PRDATA[12]|PRDATA[13]|PRDATA[15]|PRDATA[16]|PRDATA[17]|PRDATA[18]|PRDATA[19]|PRDATA[21]|PRDATA[23]|PRDATA[27]|PRDATA[28]|PRDATA[29]|PRDATA[31]|PRDATA[9]|PSLVERR|VGND
+ sky130_fd_pr__nfet_01v8 L=0.15 W=0.65 AS=0.169 AD=0.07475 PS=1.82 PD=0.88
M$1038 \$526 B|B1|B_N|Y A2|Y
+ LO|PRDATA[10]|PRDATA[12]|PRDATA[13]|PRDATA[15]|PRDATA[16]|PRDATA[17]|PRDATA[18]|PRDATA[19]|PRDATA[21]|PRDATA[23]|PRDATA[27]|PRDATA[28]|PRDATA[29]|PRDATA[31]|PRDATA[9]|PSLVERR|VGND
+ sky130_fd_pr__nfet_01v8 L=0.15 W=0.65 AS=0.07475 AD=0.169 PS=0.88 PD=1.82
M$1039 A2|Y A0|A1|Q|gpio_out[2] \$525
+ LO|PRDATA[10]|PRDATA[12]|PRDATA[13]|PRDATA[15]|PRDATA[16]|PRDATA[17]|PRDATA[18]|PRDATA[19]|PRDATA[21]|PRDATA[23]|PRDATA[27]|PRDATA[28]|PRDATA[29]|PRDATA[31]|PRDATA[9]|PSLVERR|VGND
+ sky130_fd_pr__nfet_01v8 L=0.15 W=0.65 AS=0.169 AD=0.06825 PS=1.82 PD=0.86
M$1040 \$525 A2|B|C2|Y
+ LO|PRDATA[10]|PRDATA[12]|PRDATA[13]|PRDATA[15]|PRDATA[16]|PRDATA[17]|PRDATA[18]|PRDATA[19]|PRDATA[21]|PRDATA[23]|PRDATA[27]|PRDATA[28]|PRDATA[29]|PRDATA[31]|PRDATA[9]|PSLVERR|VGND
+ LO|PRDATA[10]|PRDATA[12]|PRDATA[13]|PRDATA[15]|PRDATA[16]|PRDATA[17]|PRDATA[18]|PRDATA[19]|PRDATA[21]|PRDATA[23]|PRDATA[27]|PRDATA[28]|PRDATA[29]|PRDATA[31]|PRDATA[9]|PSLVERR|VGND
+ sky130_fd_pr__nfet_01v8 L=0.15 W=0.65 AS=0.06825 AD=0.234 PS=0.86 PD=2.02
M$1041
+ LO|PRDATA[10]|PRDATA[12]|PRDATA[13]|PRDATA[15]|PRDATA[16]|PRDATA[17]|PRDATA[18]|PRDATA[19]|PRDATA[21]|PRDATA[23]|PRDATA[27]|PRDATA[28]|PRDATA[29]|PRDATA[31]|PRDATA[9]|PSLVERR|VGND
+ A|A_N|Y \$438
+ LO|PRDATA[10]|PRDATA[12]|PRDATA[13]|PRDATA[15]|PRDATA[16]|PRDATA[17]|PRDATA[18]|PRDATA[19]|PRDATA[21]|PRDATA[23]|PRDATA[27]|PRDATA[28]|PRDATA[29]|PRDATA[31]|PRDATA[9]|PSLVERR|VGND
+ sky130_fd_pr__nfet_01v8 L=0.15 W=0.42 AS=0.1092 AD=0.1092 PS=1.36 PD=1.36
M$1042
+ LO|PRDATA[10]|PRDATA[12]|PRDATA[13]|PRDATA[15]|PRDATA[16]|PRDATA[17]|PRDATA[18]|PRDATA[19]|PRDATA[21]|PRDATA[23]|PRDATA[27]|PRDATA[28]|PRDATA[29]|PRDATA[31]|PRDATA[9]|PSLVERR|VGND
+ A|PADDR[4] A2|B|C2|Y
+ LO|PRDATA[10]|PRDATA[12]|PRDATA[13]|PRDATA[15]|PRDATA[16]|PRDATA[17]|PRDATA[18]|PRDATA[19]|PRDATA[21]|PRDATA[23]|PRDATA[27]|PRDATA[28]|PRDATA[29]|PRDATA[31]|PRDATA[9]|PSLVERR|VGND
+ sky130_fd_pr__nfet_01v8 L=0.15 W=2.6 AS=0.44525 AD=0.351 PS=4.62 PD=3.68
M$1046
+ LO|PRDATA[10]|PRDATA[12]|PRDATA[13]|PRDATA[15]|PRDATA[16]|PRDATA[17]|PRDATA[18]|PRDATA[19]|PRDATA[21]|PRDATA[23]|PRDATA[27]|PRDATA[28]|PRDATA[29]|PRDATA[31]|PRDATA[9]|PSLVERR|VGND
+ B|PADDR[5] A2|B|C2|Y
+ LO|PRDATA[10]|PRDATA[12]|PRDATA[13]|PRDATA[15]|PRDATA[16]|PRDATA[17]|PRDATA[18]|PRDATA[19]|PRDATA[21]|PRDATA[23]|PRDATA[27]|PRDATA[28]|PRDATA[29]|PRDATA[31]|PRDATA[9]|PSLVERR|VGND
+ sky130_fd_pr__nfet_01v8 L=0.15 W=2.6 AS=0.351 AD=0.52 PS=3.68 PD=4.2
M$1050
+ LO|PRDATA[10]|PRDATA[12]|PRDATA[13]|PRDATA[15]|PRDATA[16]|PRDATA[17]|PRDATA[18]|PRDATA[19]|PRDATA[21]|PRDATA[23]|PRDATA[27]|PRDATA[28]|PRDATA[29]|PRDATA[31]|PRDATA[9]|PSLVERR|VGND
+ A|A2|C|D_N|X A2|B|C2|Y
+ LO|PRDATA[10]|PRDATA[12]|PRDATA[13]|PRDATA[15]|PRDATA[16]|PRDATA[17]|PRDATA[18]|PRDATA[19]|PRDATA[21]|PRDATA[23]|PRDATA[27]|PRDATA[28]|PRDATA[29]|PRDATA[31]|PRDATA[9]|PSLVERR|VGND
+ sky130_fd_pr__nfet_01v8 L=0.15 W=2.6 AS=0.52 AD=0.351 PS=4.2 PD=3.68
M$1054
+ LO|PRDATA[10]|PRDATA[12]|PRDATA[13]|PRDATA[15]|PRDATA[16]|PRDATA[17]|PRDATA[18]|PRDATA[19]|PRDATA[21]|PRDATA[23]|PRDATA[27]|PRDATA[28]|PRDATA[29]|PRDATA[31]|PRDATA[9]|PSLVERR|VGND
+ C|C_N|D|D_N|PADDR[3] A2|B|C2|Y
+ LO|PRDATA[10]|PRDATA[12]|PRDATA[13]|PRDATA[15]|PRDATA[16]|PRDATA[17]|PRDATA[18]|PRDATA[19]|PRDATA[21]|PRDATA[23]|PRDATA[27]|PRDATA[28]|PRDATA[29]|PRDATA[31]|PRDATA[9]|PSLVERR|VGND
+ sky130_fd_pr__nfet_01v8 L=0.15 W=2.6 AS=0.351 AD=0.43225 PS=3.68 PD=4.58
M$1058 \$440 \$438 \$456
+ LO|PRDATA[10]|PRDATA[12]|PRDATA[13]|PRDATA[15]|PRDATA[16]|PRDATA[17]|PRDATA[18]|PRDATA[19]|PRDATA[21]|PRDATA[23]|PRDATA[27]|PRDATA[28]|PRDATA[29]|PRDATA[31]|PRDATA[9]|PSLVERR|VGND
+ sky130_fd_pr__nfet_01v8 L=0.15 W=0.42 AS=0.1092 AD=0.0504 PS=1.36 PD=0.66
M$1059
+ LO|PRDATA[10]|PRDATA[12]|PRDATA[13]|PRDATA[15]|PRDATA[16]|PRDATA[17]|PRDATA[18]|PRDATA[19]|PRDATA[21]|PRDATA[23]|PRDATA[27]|PRDATA[28]|PRDATA[29]|PRDATA[31]|PRDATA[9]|PSLVERR|VGND
+ A2|B|C2|Y \$456
+ LO|PRDATA[10]|PRDATA[12]|PRDATA[13]|PRDATA[15]|PRDATA[16]|PRDATA[17]|PRDATA[18]|PRDATA[19]|PRDATA[21]|PRDATA[23]|PRDATA[27]|PRDATA[28]|PRDATA[29]|PRDATA[31]|PRDATA[9]|PSLVERR|VGND
+ sky130_fd_pr__nfet_01v8 L=0.15 W=0.42 AS=0.1013 AD=0.0504 PS=0.99 PD=0.66
M$1060
+ LO|PRDATA[10]|PRDATA[12]|PRDATA[13]|PRDATA[15]|PRDATA[16]|PRDATA[17]|PRDATA[18]|PRDATA[19]|PRDATA[21]|PRDATA[23]|PRDATA[27]|PRDATA[28]|PRDATA[29]|PRDATA[31]|PRDATA[9]|PSLVERR|VGND
+ \$440 A|X
+ LO|PRDATA[10]|PRDATA[12]|PRDATA[13]|PRDATA[15]|PRDATA[16]|PRDATA[17]|PRDATA[18]|PRDATA[19]|PRDATA[21]|PRDATA[23]|PRDATA[27]|PRDATA[28]|PRDATA[29]|PRDATA[31]|PRDATA[9]|PSLVERR|VGND
+ sky130_fd_pr__nfet_01v8 L=0.15 W=0.65 AS=0.1013 AD=0.169 PS=0.99 PD=1.82
M$1061 \$458 B|B1|B_N|Y
+ LO|PRDATA[10]|PRDATA[12]|PRDATA[13]|PRDATA[15]|PRDATA[16]|PRDATA[17]|PRDATA[18]|PRDATA[19]|PRDATA[21]|PRDATA[23]|PRDATA[27]|PRDATA[28]|PRDATA[29]|PRDATA[31]|PRDATA[9]|PSLVERR|VGND
+ LO|PRDATA[10]|PRDATA[12]|PRDATA[13]|PRDATA[15]|PRDATA[16]|PRDATA[17]|PRDATA[18]|PRDATA[19]|PRDATA[21]|PRDATA[23]|PRDATA[27]|PRDATA[28]|PRDATA[29]|PRDATA[31]|PRDATA[9]|PSLVERR|VGND
+ sky130_fd_pr__nfet_01v8 L=0.15 W=0.42 AS=0.1092 AD=0.10025 PS=1.36 PD=0.985
M$1062
+ LO|PRDATA[10]|PRDATA[12]|PRDATA[13]|PRDATA[15]|PRDATA[16]|PRDATA[17]|PRDATA[18]|PRDATA[19]|PRDATA[21]|PRDATA[23]|PRDATA[27]|PRDATA[28]|PRDATA[29]|PRDATA[31]|PRDATA[9]|PSLVERR|VGND
+ A|A_N|Y A|Y
+ LO|PRDATA[10]|PRDATA[12]|PRDATA[13]|PRDATA[15]|PRDATA[16]|PRDATA[17]|PRDATA[18]|PRDATA[19]|PRDATA[21]|PRDATA[23]|PRDATA[27]|PRDATA[28]|PRDATA[29]|PRDATA[31]|PRDATA[9]|PSLVERR|VGND
+ sky130_fd_pr__nfet_01v8 L=0.15 W=0.65 AS=0.10025 AD=0.08775 PS=0.985 PD=0.92
M$1063 A|Y \$458
+ LO|PRDATA[10]|PRDATA[12]|PRDATA[13]|PRDATA[15]|PRDATA[16]|PRDATA[17]|PRDATA[18]|PRDATA[19]|PRDATA[21]|PRDATA[23]|PRDATA[27]|PRDATA[28]|PRDATA[29]|PRDATA[31]|PRDATA[9]|PSLVERR|VGND
+ LO|PRDATA[10]|PRDATA[12]|PRDATA[13]|PRDATA[15]|PRDATA[16]|PRDATA[17]|PRDATA[18]|PRDATA[19]|PRDATA[21]|PRDATA[23]|PRDATA[27]|PRDATA[28]|PRDATA[29]|PRDATA[31]|PRDATA[9]|PSLVERR|VGND
+ sky130_fd_pr__nfet_01v8 L=0.15 W=0.65 AS=0.08775 AD=0.169 PS=0.92 PD=1.82
M$1064
+ LO|PRDATA[10]|PRDATA[12]|PRDATA[13]|PRDATA[15]|PRDATA[16]|PRDATA[17]|PRDATA[18]|PRDATA[19]|PRDATA[21]|PRDATA[23]|PRDATA[27]|PRDATA[28]|PRDATA[29]|PRDATA[31]|PRDATA[9]|PSLVERR|VGND
+ A|X \$442
+ LO|PRDATA[10]|PRDATA[12]|PRDATA[13]|PRDATA[15]|PRDATA[16]|PRDATA[17]|PRDATA[18]|PRDATA[19]|PRDATA[21]|PRDATA[23]|PRDATA[27]|PRDATA[28]|PRDATA[29]|PRDATA[31]|PRDATA[9]|PSLVERR|VGND
+ sky130_fd_pr__nfet_01v8 L=0.15 W=1.3 AS=0.25675 AD=0.1755 PS=2.74 PD=1.84
M$1066
+ LO|PRDATA[10]|PRDATA[12]|PRDATA[13]|PRDATA[15]|PRDATA[16]|PRDATA[17]|PRDATA[18]|PRDATA[19]|PRDATA[21]|PRDATA[23]|PRDATA[27]|PRDATA[28]|PRDATA[29]|PRDATA[31]|PRDATA[9]|PSLVERR|VGND
+ \$442 S|X
+ LO|PRDATA[10]|PRDATA[12]|PRDATA[13]|PRDATA[15]|PRDATA[16]|PRDATA[17]|PRDATA[18]|PRDATA[19]|PRDATA[21]|PRDATA[23]|PRDATA[27]|PRDATA[28]|PRDATA[29]|PRDATA[31]|PRDATA[9]|PSLVERR|VGND
+ sky130_fd_pr__nfet_01v8 L=0.15 W=3.9 AS=0.5265 AD=0.60775 PS=5.52 PD=6.42
M$1072
+ LO|PRDATA[10]|PRDATA[12]|PRDATA[13]|PRDATA[15]|PRDATA[16]|PRDATA[17]|PRDATA[18]|PRDATA[19]|PRDATA[21]|PRDATA[23]|PRDATA[27]|PRDATA[28]|PRDATA[29]|PRDATA[31]|PRDATA[9]|PSLVERR|VGND
+ B|B1|Y \$524
+ LO|PRDATA[10]|PRDATA[12]|PRDATA[13]|PRDATA[15]|PRDATA[16]|PRDATA[17]|PRDATA[18]|PRDATA[19]|PRDATA[21]|PRDATA[23]|PRDATA[27]|PRDATA[28]|PRDATA[29]|PRDATA[31]|PRDATA[9]|PSLVERR|VGND
+ sky130_fd_pr__nfet_01v8 L=0.15 W=0.65 AS=0.169 AD=0.08775 PS=1.82 PD=0.92
M$1073 \$524 A|A2|C|D_N|X B|Y
+ LO|PRDATA[10]|PRDATA[12]|PRDATA[13]|PRDATA[15]|PRDATA[16]|PRDATA[17]|PRDATA[18]|PRDATA[19]|PRDATA[21]|PRDATA[23]|PRDATA[27]|PRDATA[28]|PRDATA[29]|PRDATA[31]|PRDATA[9]|PSLVERR|VGND
+ sky130_fd_pr__nfet_01v8 L=0.15 W=0.65 AS=0.08775 AD=0.169 PS=0.92 PD=1.82
M$1074 \$444 A_N|C|PWRITE
+ LO|PRDATA[10]|PRDATA[12]|PRDATA[13]|PRDATA[15]|PRDATA[16]|PRDATA[17]|PRDATA[18]|PRDATA[19]|PRDATA[21]|PRDATA[23]|PRDATA[27]|PRDATA[28]|PRDATA[29]|PRDATA[31]|PRDATA[9]|PSLVERR|VGND
+ LO|PRDATA[10]|PRDATA[12]|PRDATA[13]|PRDATA[15]|PRDATA[16]|PRDATA[17]|PRDATA[18]|PRDATA[19]|PRDATA[21]|PRDATA[23]|PRDATA[27]|PRDATA[28]|PRDATA[29]|PRDATA[31]|PRDATA[9]|PSLVERR|VGND
+ sky130_fd_pr__nfet_01v8 L=0.15 W=0.42 AS=0.1092 AD=0.10025 PS=1.36 PD=0.985
M$1075
+ LO|PRDATA[10]|PRDATA[12]|PRDATA[13]|PRDATA[15]|PRDATA[16]|PRDATA[17]|PRDATA[18]|PRDATA[19]|PRDATA[21]|PRDATA[23]|PRDATA[27]|PRDATA[28]|PRDATA[29]|PRDATA[31]|PRDATA[9]|PSLVERR|VGND
+ B|PREADY|X \$453
+ LO|PRDATA[10]|PRDATA[12]|PRDATA[13]|PRDATA[15]|PRDATA[16]|PRDATA[17]|PRDATA[18]|PRDATA[19]|PRDATA[21]|PRDATA[23]|PRDATA[27]|PRDATA[28]|PRDATA[29]|PRDATA[31]|PRDATA[9]|PSLVERR|VGND
+ sky130_fd_pr__nfet_01v8 L=0.15 W=0.65 AS=0.10025 AD=0.08775 PS=0.985 PD=0.92
M$1076 \$453 \$444 A|Y
+ LO|PRDATA[10]|PRDATA[12]|PRDATA[13]|PRDATA[15]|PRDATA[16]|PRDATA[17]|PRDATA[18]|PRDATA[19]|PRDATA[21]|PRDATA[23]|PRDATA[27]|PRDATA[28]|PRDATA[29]|PRDATA[31]|PRDATA[9]|PSLVERR|VGND
+ sky130_fd_pr__nfet_01v8 L=0.15 W=0.65 AS=0.08775 AD=0.169 PS=0.92 PD=1.82
M$1077
+ LO|PRDATA[10]|PRDATA[12]|PRDATA[13]|PRDATA[15]|PRDATA[16]|PRDATA[17]|PRDATA[18]|PRDATA[19]|PRDATA[21]|PRDATA[23]|PRDATA[27]|PRDATA[28]|PRDATA[29]|PRDATA[31]|PRDATA[9]|PSLVERR|VGND
+ A|B1|X PRDATA[8]|Y
+ LO|PRDATA[10]|PRDATA[12]|PRDATA[13]|PRDATA[15]|PRDATA[16]|PRDATA[17]|PRDATA[18]|PRDATA[19]|PRDATA[21]|PRDATA[23]|PRDATA[27]|PRDATA[28]|PRDATA[29]|PRDATA[31]|PRDATA[9]|PSLVERR|VGND
+ sky130_fd_pr__nfet_01v8 L=0.15 W=1.3 AS=0.26975 AD=0.1755 PS=2.78 PD=1.84
M$1079
+ LO|PRDATA[10]|PRDATA[12]|PRDATA[13]|PRDATA[15]|PRDATA[16]|PRDATA[17]|PRDATA[18]|PRDATA[19]|PRDATA[21]|PRDATA[23]|PRDATA[27]|PRDATA[28]|PRDATA[29]|PRDATA[31]|PRDATA[9]|PSLVERR|VGND
+ B|Y PRDATA[8]|Y
+ LO|PRDATA[10]|PRDATA[12]|PRDATA[13]|PRDATA[15]|PRDATA[16]|PRDATA[17]|PRDATA[18]|PRDATA[19]|PRDATA[21]|PRDATA[23]|PRDATA[27]|PRDATA[28]|PRDATA[29]|PRDATA[31]|PRDATA[9]|PSLVERR|VGND
+ sky130_fd_pr__nfet_01v8 L=0.15 W=1.3 AS=0.1755 AD=0.25675 PS=1.84 PD=2.74
M$1081 \$447 A|PSEL \$452
+ LO|PRDATA[10]|PRDATA[12]|PRDATA[13]|PRDATA[15]|PRDATA[16]|PRDATA[17]|PRDATA[18]|PRDATA[19]|PRDATA[21]|PRDATA[23]|PRDATA[27]|PRDATA[28]|PRDATA[29]|PRDATA[31]|PRDATA[9]|PSLVERR|VGND
+ sky130_fd_pr__nfet_01v8 L=0.15 W=0.42 AS=0.1176 AD=0.0567 PS=1.4 PD=0.69
M$1082
+ LO|PRDATA[10]|PRDATA[12]|PRDATA[13]|PRDATA[15]|PRDATA[16]|PRDATA[17]|PRDATA[18]|PRDATA[19]|PRDATA[21]|PRDATA[23]|PRDATA[27]|PRDATA[28]|PRDATA[29]|PRDATA[31]|PRDATA[9]|PSLVERR|VGND
+ B|PENABLE \$452
+ LO|PRDATA[10]|PRDATA[12]|PRDATA[13]|PRDATA[15]|PRDATA[16]|PRDATA[17]|PRDATA[18]|PRDATA[19]|PRDATA[21]|PRDATA[23]|PRDATA[27]|PRDATA[28]|PRDATA[29]|PRDATA[31]|PRDATA[9]|PSLVERR|VGND
+ sky130_fd_pr__nfet_01v8 L=0.15 W=0.42 AS=0.1118 AD=0.0567 PS=1.04 PD=0.69
M$1083
+ LO|PRDATA[10]|PRDATA[12]|PRDATA[13]|PRDATA[15]|PRDATA[16]|PRDATA[17]|PRDATA[18]|PRDATA[19]|PRDATA[21]|PRDATA[23]|PRDATA[27]|PRDATA[28]|PRDATA[29]|PRDATA[31]|PRDATA[9]|PSLVERR|VGND
+ \$447 A|X
+ LO|PRDATA[10]|PRDATA[12]|PRDATA[13]|PRDATA[15]|PRDATA[16]|PRDATA[17]|PRDATA[18]|PRDATA[19]|PRDATA[21]|PRDATA[23]|PRDATA[27]|PRDATA[28]|PRDATA[29]|PRDATA[31]|PRDATA[9]|PSLVERR|VGND
+ sky130_fd_pr__nfet_01v8 L=0.15 W=0.65 AS=0.1118 AD=0.182 PS=1.04 PD=1.86
M$1084
+ LO|PRDATA[10]|PRDATA[12]|PRDATA[13]|PRDATA[15]|PRDATA[16]|PRDATA[17]|PRDATA[18]|PRDATA[19]|PRDATA[21]|PRDATA[23]|PRDATA[27]|PRDATA[28]|PRDATA[29]|PRDATA[31]|PRDATA[9]|PSLVERR|VGND
+ A_N|C|PWRITE \$498
+ LO|PRDATA[10]|PRDATA[12]|PRDATA[13]|PRDATA[15]|PRDATA[16]|PRDATA[17]|PRDATA[18]|PRDATA[19]|PRDATA[21]|PRDATA[23]|PRDATA[27]|PRDATA[28]|PRDATA[29]|PRDATA[31]|PRDATA[9]|PSLVERR|VGND
+ sky130_fd_pr__nfet_01v8 L=0.15 W=0.65 AS=0.169 AD=0.08775 PS=1.82 PD=0.92
M$1085 \$498 B|PENABLE \$492
+ LO|PRDATA[10]|PRDATA[12]|PRDATA[13]|PRDATA[15]|PRDATA[16]|PRDATA[17]|PRDATA[18]|PRDATA[19]|PRDATA[21]|PRDATA[23]|PRDATA[27]|PRDATA[28]|PRDATA[29]|PRDATA[31]|PRDATA[9]|PSLVERR|VGND
+ sky130_fd_pr__nfet_01v8 L=0.15 W=0.65 AS=0.08775 AD=0.10725 PS=0.92 PD=0.98
M$1086 \$492 A|PSEL A|A_N|Y
+ LO|PRDATA[10]|PRDATA[12]|PRDATA[13]|PRDATA[15]|PRDATA[16]|PRDATA[17]|PRDATA[18]|PRDATA[19]|PRDATA[21]|PRDATA[23]|PRDATA[27]|PRDATA[28]|PRDATA[29]|PRDATA[31]|PRDATA[9]|PSLVERR|VGND
+ sky130_fd_pr__nfet_01v8 L=0.15 W=0.65 AS=0.10725 AD=0.169 PS=0.98 PD=1.82
M$1087
+ LO|PRDATA[10]|PRDATA[12]|PRDATA[13]|PRDATA[15]|PRDATA[16]|PRDATA[17]|PRDATA[18]|PRDATA[19]|PRDATA[21]|PRDATA[23]|PRDATA[27]|PRDATA[28]|PRDATA[29]|PRDATA[31]|PRDATA[9]|PSLVERR|VGND
+ A|Y \$449
+ LO|PRDATA[10]|PRDATA[12]|PRDATA[13]|PRDATA[15]|PRDATA[16]|PRDATA[17]|PRDATA[18]|PRDATA[19]|PRDATA[21]|PRDATA[23]|PRDATA[27]|PRDATA[28]|PRDATA[29]|PRDATA[31]|PRDATA[9]|PSLVERR|VGND
+ sky130_fd_pr__nfet_01v8 L=0.15 W=0.42 AS=0.097 AD=0.1092 PS=0.975 PD=1.36
M$1088
+ LO|PRDATA[10]|PRDATA[12]|PRDATA[13]|PRDATA[15]|PRDATA[16]|PRDATA[17]|PRDATA[18]|PRDATA[19]|PRDATA[21]|PRDATA[23]|PRDATA[27]|PRDATA[28]|PRDATA[29]|PRDATA[31]|PRDATA[9]|PSLVERR|VGND
+ \$449 A|B1|X
+ LO|PRDATA[10]|PRDATA[12]|PRDATA[13]|PRDATA[15]|PRDATA[16]|PRDATA[17]|PRDATA[18]|PRDATA[19]|PRDATA[21]|PRDATA[23]|PRDATA[27]|PRDATA[28]|PRDATA[29]|PRDATA[31]|PRDATA[9]|PSLVERR|VGND
+ sky130_fd_pr__nfet_01v8 L=0.15 W=1.3 AS=0.18475 AD=0.26 PS=1.895 PD=2.75
M$1090 \$528 A|X
+ LO|PRDATA[10]|PRDATA[12]|PRDATA[13]|PRDATA[15]|PRDATA[16]|PRDATA[17]|PRDATA[18]|PRDATA[19]|PRDATA[21]|PRDATA[23]|PRDATA[27]|PRDATA[28]|PRDATA[29]|PRDATA[31]|PRDATA[9]|PSLVERR|VGND
+ LO|PRDATA[10]|PRDATA[12]|PRDATA[13]|PRDATA[15]|PRDATA[16]|PRDATA[17]|PRDATA[18]|PRDATA[19]|PRDATA[21]|PRDATA[23]|PRDATA[27]|PRDATA[28]|PRDATA[29]|PRDATA[31]|PRDATA[9]|PSLVERR|VGND
+ sky130_fd_pr__nfet_01v8 L=0.15 W=0.65 AS=0.169 AD=0.08775 PS=1.82 PD=0.92
M$1091
+ LO|PRDATA[10]|PRDATA[12]|PRDATA[13]|PRDATA[15]|PRDATA[16]|PRDATA[17]|PRDATA[18]|PRDATA[19]|PRDATA[21]|PRDATA[23]|PRDATA[27]|PRDATA[28]|PRDATA[29]|PRDATA[31]|PRDATA[9]|PSLVERR|VGND
+ \$528 D|X
+ LO|PRDATA[10]|PRDATA[12]|PRDATA[13]|PRDATA[15]|PRDATA[16]|PRDATA[17]|PRDATA[18]|PRDATA[19]|PRDATA[21]|PRDATA[23]|PRDATA[27]|PRDATA[28]|PRDATA[29]|PRDATA[31]|PRDATA[9]|PSLVERR|VGND
+ sky130_fd_pr__nfet_01v8 L=0.15 W=2.6 AS=0.351 AD=0.43225 PS=3.68 PD=4.58
M$1095 \$530 CLK|X
+ LO|PRDATA[10]|PRDATA[12]|PRDATA[13]|PRDATA[15]|PRDATA[16]|PRDATA[17]|PRDATA[18]|PRDATA[19]|PRDATA[21]|PRDATA[23]|PRDATA[27]|PRDATA[28]|PRDATA[29]|PRDATA[31]|PRDATA[9]|PSLVERR|VGND
+ LO|PRDATA[10]|PRDATA[12]|PRDATA[13]|PRDATA[15]|PRDATA[16]|PRDATA[17]|PRDATA[18]|PRDATA[19]|PRDATA[21]|PRDATA[23]|PRDATA[27]|PRDATA[28]|PRDATA[29]|PRDATA[31]|PRDATA[9]|PSLVERR|VGND
+ sky130_fd_pr__nfet_01v8 L=0.15 W=0.42 AS=0.1092 AD=0.0567 PS=1.36 PD=0.69
M$1096
+ LO|PRDATA[10]|PRDATA[12]|PRDATA[13]|PRDATA[15]|PRDATA[16]|PRDATA[17]|PRDATA[18]|PRDATA[19]|PRDATA[21]|PRDATA[23]|PRDATA[27]|PRDATA[28]|PRDATA[29]|PRDATA[31]|PRDATA[9]|PSLVERR|VGND
+ \$530 \$531
+ LO|PRDATA[10]|PRDATA[12]|PRDATA[13]|PRDATA[15]|PRDATA[16]|PRDATA[17]|PRDATA[18]|PRDATA[19]|PRDATA[21]|PRDATA[23]|PRDATA[27]|PRDATA[28]|PRDATA[29]|PRDATA[31]|PRDATA[9]|PSLVERR|VGND
+ sky130_fd_pr__nfet_01v8 L=0.15 W=0.42 AS=0.0567 AD=0.1092 PS=0.69 PD=1.36
M$1097 \$532 \$530 \$533
+ LO|PRDATA[10]|PRDATA[12]|PRDATA[13]|PRDATA[15]|PRDATA[16]|PRDATA[17]|PRDATA[18]|PRDATA[19]|PRDATA[21]|PRDATA[23]|PRDATA[27]|PRDATA[28]|PRDATA[29]|PRDATA[31]|PRDATA[9]|PSLVERR|VGND
+ sky130_fd_pr__nfet_01v8 L=0.15 W=0.36 AS=0.066 AD=0.0594 PS=0.745 PD=0.69
M$1098 \$533 \$531 \$586
+ LO|PRDATA[10]|PRDATA[12]|PRDATA[13]|PRDATA[15]|PRDATA[16]|PRDATA[17]|PRDATA[18]|PRDATA[19]|PRDATA[21]|PRDATA[23]|PRDATA[27]|PRDATA[28]|PRDATA[29]|PRDATA[31]|PRDATA[9]|PSLVERR|VGND
+ sky130_fd_pr__nfet_01v8 L=0.15 W=0.36 AS=0.0594 AD=0.1401 PS=0.69 PD=1.1
M$1099 \$593 \$531 \$534
+ LO|PRDATA[10]|PRDATA[12]|PRDATA[13]|PRDATA[15]|PRDATA[16]|PRDATA[17]|PRDATA[18]|PRDATA[19]|PRDATA[21]|PRDATA[23]|PRDATA[27]|PRDATA[28]|PRDATA[29]|PRDATA[31]|PRDATA[9]|PSLVERR|VGND
+ sky130_fd_pr__nfet_01v8 L=0.15 W=0.36 AS=0.0999 AD=0.0711 PS=0.985 PD=0.755
M$1100 \$534 \$530 \$588
+ LO|PRDATA[10]|PRDATA[12]|PRDATA[13]|PRDATA[15]|PRDATA[16]|PRDATA[17]|PRDATA[18]|PRDATA[19]|PRDATA[21]|PRDATA[23]|PRDATA[27]|PRDATA[28]|PRDATA[29]|PRDATA[31]|PRDATA[9]|PSLVERR|VGND
+ sky130_fd_pr__nfet_01v8 L=0.15 W=0.36 AS=0.0711 AD=0.0669 PS=0.755 PD=0.75
M$1101
+ LO|PRDATA[10]|PRDATA[12]|PRDATA[13]|PRDATA[15]|PRDATA[16]|PRDATA[17]|PRDATA[18]|PRDATA[19]|PRDATA[21]|PRDATA[23]|PRDATA[27]|PRDATA[28]|PRDATA[29]|PRDATA[31]|PRDATA[9]|PSLVERR|VGND
+ D|X \$532
+ LO|PRDATA[10]|PRDATA[12]|PRDATA[13]|PRDATA[15]|PRDATA[16]|PRDATA[17]|PRDATA[18]|PRDATA[19]|PRDATA[21]|PRDATA[23]|PRDATA[27]|PRDATA[28]|PRDATA[29]|PRDATA[31]|PRDATA[9]|PSLVERR|VGND
+ sky130_fd_pr__nfet_01v8 L=0.15 W=0.42 AS=0.2205 AD=0.066 PS=1.89 PD=0.745
M$1102 \$586 \$593 \$587
+ LO|PRDATA[10]|PRDATA[12]|PRDATA[13]|PRDATA[15]|PRDATA[16]|PRDATA[17]|PRDATA[18]|PRDATA[19]|PRDATA[21]|PRDATA[23]|PRDATA[27]|PRDATA[28]|PRDATA[29]|PRDATA[31]|PRDATA[9]|PSLVERR|VGND
+ sky130_fd_pr__nfet_01v8 L=0.15 W=0.42 AS=0.1401 AD=0.0441 PS=1.1 PD=0.63
M$1103 \$587 PRESETn|RESET_B
+ LO|PRDATA[10]|PRDATA[12]|PRDATA[13]|PRDATA[15]|PRDATA[16]|PRDATA[17]|PRDATA[18]|PRDATA[19]|PRDATA[21]|PRDATA[23]|PRDATA[27]|PRDATA[28]|PRDATA[29]|PRDATA[31]|PRDATA[9]|PSLVERR|VGND
+ LO|PRDATA[10]|PRDATA[12]|PRDATA[13]|PRDATA[15]|PRDATA[16]|PRDATA[17]|PRDATA[18]|PRDATA[19]|PRDATA[21]|PRDATA[23]|PRDATA[27]|PRDATA[28]|PRDATA[29]|PRDATA[31]|PRDATA[9]|PSLVERR|VGND
+ sky130_fd_pr__nfet_01v8 L=0.15 W=0.42 AS=0.0441 AD=0.1346 PS=0.63 PD=1.15
M$1104 \$588 \$535
+ LO|PRDATA[10]|PRDATA[12]|PRDATA[13]|PRDATA[15]|PRDATA[16]|PRDATA[17]|PRDATA[18]|PRDATA[19]|PRDATA[21]|PRDATA[23]|PRDATA[27]|PRDATA[28]|PRDATA[29]|PRDATA[31]|PRDATA[9]|PSLVERR|VGND
+ LO|PRDATA[10]|PRDATA[12]|PRDATA[13]|PRDATA[15]|PRDATA[16]|PRDATA[17]|PRDATA[18]|PRDATA[19]|PRDATA[21]|PRDATA[23]|PRDATA[27]|PRDATA[28]|PRDATA[29]|PRDATA[31]|PRDATA[9]|PSLVERR|VGND
+ sky130_fd_pr__nfet_01v8 L=0.15 W=0.42 AS=0.0669 AD=0.12495 PS=0.75 PD=1.015
M$1105
+ LO|PRDATA[10]|PRDATA[12]|PRDATA[13]|PRDATA[15]|PRDATA[16]|PRDATA[17]|PRDATA[18]|PRDATA[19]|PRDATA[21]|PRDATA[23]|PRDATA[27]|PRDATA[28]|PRDATA[29]|PRDATA[31]|PRDATA[9]|PSLVERR|VGND
+ PRESETn|RESET_B \$589
+ LO|PRDATA[10]|PRDATA[12]|PRDATA[13]|PRDATA[15]|PRDATA[16]|PRDATA[17]|PRDATA[18]|PRDATA[19]|PRDATA[21]|PRDATA[23]|PRDATA[27]|PRDATA[28]|PRDATA[29]|PRDATA[31]|PRDATA[9]|PSLVERR|VGND
+ sky130_fd_pr__nfet_01v8 L=0.15 W=0.42 AS=0.12495 AD=0.06405 PS=1.015 PD=0.725
M$1106 \$589 \$534 \$535
+ LO|PRDATA[10]|PRDATA[12]|PRDATA[13]|PRDATA[15]|PRDATA[16]|PRDATA[17]|PRDATA[18]|PRDATA[19]|PRDATA[21]|PRDATA[23]|PRDATA[27]|PRDATA[28]|PRDATA[29]|PRDATA[31]|PRDATA[9]|PSLVERR|VGND
+ sky130_fd_pr__nfet_01v8 L=0.15 W=0.42 AS=0.06405 AD=0.1092 PS=0.725 PD=1.36
M$1107
+ LO|PRDATA[10]|PRDATA[12]|PRDATA[13]|PRDATA[15]|PRDATA[16]|PRDATA[17]|PRDATA[18]|PRDATA[19]|PRDATA[21]|PRDATA[23]|PRDATA[27]|PRDATA[28]|PRDATA[29]|PRDATA[31]|PRDATA[9]|PSLVERR|VGND
+ \$533 \$593
+ LO|PRDATA[10]|PRDATA[12]|PRDATA[13]|PRDATA[15]|PRDATA[16]|PRDATA[17]|PRDATA[18]|PRDATA[19]|PRDATA[21]|PRDATA[23]|PRDATA[27]|PRDATA[28]|PRDATA[29]|PRDATA[31]|PRDATA[9]|PSLVERR|VGND
+ sky130_fd_pr__nfet_01v8 L=0.15 W=0.64 AS=0.1346 AD=0.0999 PS=1.15 PD=0.985
M$1108
+ LO|PRDATA[10]|PRDATA[12]|PRDATA[13]|PRDATA[15]|PRDATA[16]|PRDATA[17]|PRDATA[18]|PRDATA[19]|PRDATA[21]|PRDATA[23]|PRDATA[27]|PRDATA[28]|PRDATA[29]|PRDATA[31]|PRDATA[9]|PSLVERR|VGND
+ \$535 A0|B2|Q|gpio_oe[2]
+ LO|PRDATA[10]|PRDATA[12]|PRDATA[13]|PRDATA[15]|PRDATA[16]|PRDATA[17]|PRDATA[18]|PRDATA[19]|PRDATA[21]|PRDATA[23]|PRDATA[27]|PRDATA[28]|PRDATA[29]|PRDATA[31]|PRDATA[9]|PSLVERR|VGND
+ sky130_fd_pr__nfet_01v8 L=0.15 W=0.65 AS=0.2087 AD=0.169 PS=2.02 PD=1.82
M$1109
+ LO|PRDATA[10]|PRDATA[12]|PRDATA[13]|PRDATA[15]|PRDATA[16]|PRDATA[17]|PRDATA[18]|PRDATA[19]|PRDATA[21]|PRDATA[23]|PRDATA[27]|PRDATA[28]|PRDATA[29]|PRDATA[31]|PRDATA[9]|PSLVERR|VGND
+ A2|Y \$591
+ LO|PRDATA[10]|PRDATA[12]|PRDATA[13]|PRDATA[15]|PRDATA[16]|PRDATA[17]|PRDATA[18]|PRDATA[19]|PRDATA[21]|PRDATA[23]|PRDATA[27]|PRDATA[28]|PRDATA[29]|PRDATA[31]|PRDATA[9]|PSLVERR|VGND
+ sky130_fd_pr__nfet_01v8 L=0.15 W=0.65 AS=0.18525 AD=0.089375 PS=1.87 PD=0.925
M$1110 \$591 A1|Y PRDATA[2]|Y
+ LO|PRDATA[10]|PRDATA[12]|PRDATA[13]|PRDATA[15]|PRDATA[16]|PRDATA[17]|PRDATA[18]|PRDATA[19]|PRDATA[21]|PRDATA[23]|PRDATA[27]|PRDATA[28]|PRDATA[29]|PRDATA[31]|PRDATA[9]|PSLVERR|VGND
+ sky130_fd_pr__nfet_01v8 L=0.15 W=0.65 AS=0.089375 AD=0.091 PS=0.925 PD=0.93
M$1111 PRDATA[2]|Y A1|Y \$592
+ LO|PRDATA[10]|PRDATA[12]|PRDATA[13]|PRDATA[15]|PRDATA[16]|PRDATA[17]|PRDATA[18]|PRDATA[19]|PRDATA[21]|PRDATA[23]|PRDATA[27]|PRDATA[28]|PRDATA[29]|PRDATA[31]|PRDATA[9]|PSLVERR|VGND
+ sky130_fd_pr__nfet_01v8 L=0.15 W=0.65 AS=0.091 AD=0.06825 PS=0.93 PD=0.86
M$1112 \$592 A2|Y
+ LO|PRDATA[10]|PRDATA[12]|PRDATA[13]|PRDATA[15]|PRDATA[16]|PRDATA[17]|PRDATA[18]|PRDATA[19]|PRDATA[21]|PRDATA[23]|PRDATA[27]|PRDATA[28]|PRDATA[29]|PRDATA[31]|PRDATA[9]|PSLVERR|VGND
+ LO|PRDATA[10]|PRDATA[12]|PRDATA[13]|PRDATA[15]|PRDATA[16]|PRDATA[17]|PRDATA[18]|PRDATA[19]|PRDATA[21]|PRDATA[23]|PRDATA[27]|PRDATA[28]|PRDATA[29]|PRDATA[31]|PRDATA[9]|PSLVERR|VGND
+ sky130_fd_pr__nfet_01v8 L=0.15 W=0.65 AS=0.06825 AD=0.10725 PS=0.86 PD=0.98
M$1113
+ LO|PRDATA[10]|PRDATA[12]|PRDATA[13]|PRDATA[15]|PRDATA[16]|PRDATA[17]|PRDATA[18]|PRDATA[19]|PRDATA[21]|PRDATA[23]|PRDATA[27]|PRDATA[28]|PRDATA[29]|PRDATA[31]|PRDATA[9]|PSLVERR|VGND
+ A|B1|X PRDATA[2]|Y
+ LO|PRDATA[10]|PRDATA[12]|PRDATA[13]|PRDATA[15]|PRDATA[16]|PRDATA[17]|PRDATA[18]|PRDATA[19]|PRDATA[21]|PRDATA[23]|PRDATA[27]|PRDATA[28]|PRDATA[29]|PRDATA[31]|PRDATA[9]|PSLVERR|VGND
+ sky130_fd_pr__nfet_01v8 L=0.15 W=1.3 AS=0.195 AD=0.34775 PS=1.9 PD=3.02
M$1115
+ LO|PRDATA[10]|PRDATA[12]|PRDATA[13]|PRDATA[15]|PRDATA[16]|PRDATA[17]|PRDATA[18]|PRDATA[19]|PRDATA[21]|PRDATA[23]|PRDATA[27]|PRDATA[28]|PRDATA[29]|PRDATA[31]|PRDATA[9]|PSLVERR|VGND
+ A|PCLK \$538
+ LO|PRDATA[10]|PRDATA[12]|PRDATA[13]|PRDATA[15]|PRDATA[16]|PRDATA[17]|PRDATA[18]|PRDATA[19]|PRDATA[21]|PRDATA[23]|PRDATA[27]|PRDATA[28]|PRDATA[29]|PRDATA[31]|PRDATA[9]|PSLVERR|VGND
+ sky130_fd_pr__nfet_01v8 L=0.15 W=1.68 AS=0.2877 AD=0.2352 PS=3.47 PD=2.8
M$1119
+ LO|PRDATA[10]|PRDATA[12]|PRDATA[13]|PRDATA[15]|PRDATA[16]|PRDATA[17]|PRDATA[18]|PRDATA[19]|PRDATA[21]|PRDATA[23]|PRDATA[27]|PRDATA[28]|PRDATA[29]|PRDATA[31]|PRDATA[9]|PSLVERR|VGND
+ \$538 A|X
+ LO|PRDATA[10]|PRDATA[12]|PRDATA[13]|PRDATA[15]|PRDATA[16]|PRDATA[17]|PRDATA[18]|PRDATA[19]|PRDATA[21]|PRDATA[23]|PRDATA[27]|PRDATA[28]|PRDATA[29]|PRDATA[31]|PRDATA[9]|PSLVERR|VGND
+ sky130_fd_pr__nfet_01v8 L=0.15 W=6.72 AS=0.93975 AD=0.99225 PS=11.195
+ PD=11.865
M$1135 \$522 A1|gpio_in[2]
+ LO|PRDATA[10]|PRDATA[12]|PRDATA[13]|PRDATA[15]|PRDATA[16]|PRDATA[17]|PRDATA[18]|PRDATA[19]|PRDATA[21]|PRDATA[23]|PRDATA[27]|PRDATA[28]|PRDATA[29]|PRDATA[31]|PRDATA[9]|PSLVERR|VGND
+ LO|PRDATA[10]|PRDATA[12]|PRDATA[13]|PRDATA[15]|PRDATA[16]|PRDATA[17]|PRDATA[18]|PRDATA[19]|PRDATA[21]|PRDATA[23]|PRDATA[27]|PRDATA[28]|PRDATA[29]|PRDATA[31]|PRDATA[9]|PSLVERR|VGND
+ sky130_fd_pr__nfet_01v8 L=0.15 W=0.42 AS=0.1113 AD=0.0588 PS=1.37 PD=0.7
M$1136
+ LO|PRDATA[10]|PRDATA[12]|PRDATA[13]|PRDATA[15]|PRDATA[16]|PRDATA[17]|PRDATA[18]|PRDATA[19]|PRDATA[21]|PRDATA[23]|PRDATA[27]|PRDATA[28]|PRDATA[29]|PRDATA[31]|PRDATA[9]|PSLVERR|VGND
+ A|A2|C|D_N|X \$522
+ LO|PRDATA[10]|PRDATA[12]|PRDATA[13]|PRDATA[15]|PRDATA[16]|PRDATA[17]|PRDATA[18]|PRDATA[19]|PRDATA[21]|PRDATA[23]|PRDATA[27]|PRDATA[28]|PRDATA[29]|PRDATA[31]|PRDATA[9]|PSLVERR|VGND
+ sky130_fd_pr__nfet_01v8 L=0.15 W=0.42 AS=0.0588 AD=0.0588 PS=0.7 PD=0.7
M$1137 \$522 B|B1|Y A1|Y
+ LO|PRDATA[10]|PRDATA[12]|PRDATA[13]|PRDATA[15]|PRDATA[16]|PRDATA[17]|PRDATA[18]|PRDATA[19]|PRDATA[21]|PRDATA[23]|PRDATA[27]|PRDATA[28]|PRDATA[29]|PRDATA[31]|PRDATA[9]|PSLVERR|VGND
+ sky130_fd_pr__nfet_01v8 L=0.15 W=0.42 AS=0.0588 AD=0.1113 PS=0.7 PD=1.37
M$1138
+ LO|PRDATA[10]|PRDATA[12]|PRDATA[13]|PRDATA[15]|PRDATA[16]|PRDATA[17]|PRDATA[18]|PRDATA[19]|PRDATA[21]|PRDATA[23]|PRDATA[27]|PRDATA[28]|PRDATA[29]|PRDATA[31]|PRDATA[9]|PSLVERR|VGND
+ \$582 A2|B1|Y
+ LO|PRDATA[10]|PRDATA[12]|PRDATA[13]|PRDATA[15]|PRDATA[16]|PRDATA[17]|PRDATA[18]|PRDATA[19]|PRDATA[21]|PRDATA[23]|PRDATA[27]|PRDATA[28]|PRDATA[29]|PRDATA[31]|PRDATA[9]|PSLVERR|VGND
+ sky130_fd_pr__nfet_01v8 L=0.15 W=0.65 AS=0.182 AD=0.08775 PS=1.86 PD=0.92
M$1139 A2|B1|Y A|A2|C|D_N|X
+ LO|PRDATA[10]|PRDATA[12]|PRDATA[13]|PRDATA[15]|PRDATA[16]|PRDATA[17]|PRDATA[18]|PRDATA[19]|PRDATA[21]|PRDATA[23]|PRDATA[27]|PRDATA[28]|PRDATA[29]|PRDATA[31]|PRDATA[9]|PSLVERR|VGND
+ LO|PRDATA[10]|PRDATA[12]|PRDATA[13]|PRDATA[15]|PRDATA[16]|PRDATA[17]|PRDATA[18]|PRDATA[19]|PRDATA[21]|PRDATA[23]|PRDATA[27]|PRDATA[28]|PRDATA[29]|PRDATA[31]|PRDATA[9]|PSLVERR|VGND
+ sky130_fd_pr__nfet_01v8 L=0.15 W=0.65 AS=0.08775 AD=0.10725 PS=0.92 PD=0.98
M$1140
+ LO|PRDATA[10]|PRDATA[12]|PRDATA[13]|PRDATA[15]|PRDATA[16]|PRDATA[17]|PRDATA[18]|PRDATA[19]|PRDATA[21]|PRDATA[23]|PRDATA[27]|PRDATA[28]|PRDATA[29]|PRDATA[31]|PRDATA[9]|PSLVERR|VGND
+ B|PADDR[5] A2|B1|Y
+ LO|PRDATA[10]|PRDATA[12]|PRDATA[13]|PRDATA[15]|PRDATA[16]|PRDATA[17]|PRDATA[18]|PRDATA[19]|PRDATA[21]|PRDATA[23]|PRDATA[27]|PRDATA[28]|PRDATA[29]|PRDATA[31]|PRDATA[9]|PSLVERR|VGND
+ sky130_fd_pr__nfet_01v8 L=0.15 W=0.65 AS=0.10725 AD=0.08775 PS=0.98 PD=0.92
M$1141 A2|B1|Y A|PADDR[4]
+ LO|PRDATA[10]|PRDATA[12]|PRDATA[13]|PRDATA[15]|PRDATA[16]|PRDATA[17]|PRDATA[18]|PRDATA[19]|PRDATA[21]|PRDATA[23]|PRDATA[27]|PRDATA[28]|PRDATA[29]|PRDATA[31]|PRDATA[9]|PSLVERR|VGND
+ LO|PRDATA[10]|PRDATA[12]|PRDATA[13]|PRDATA[15]|PRDATA[16]|PRDATA[17]|PRDATA[18]|PRDATA[19]|PRDATA[21]|PRDATA[23]|PRDATA[27]|PRDATA[28]|PRDATA[29]|PRDATA[31]|PRDATA[9]|PSLVERR|VGND
+ sky130_fd_pr__nfet_01v8 L=0.15 W=0.65 AS=0.08775 AD=0.10025 PS=0.92 PD=0.985
M$1142
+ LO|PRDATA[10]|PRDATA[12]|PRDATA[13]|PRDATA[15]|PRDATA[16]|PRDATA[17]|PRDATA[18]|PRDATA[19]|PRDATA[21]|PRDATA[23]|PRDATA[27]|PRDATA[28]|PRDATA[29]|PRDATA[31]|PRDATA[9]|PSLVERR|VGND
+ C|C_N|D|D_N|PADDR[3] \$582
+ LO|PRDATA[10]|PRDATA[12]|PRDATA[13]|PRDATA[15]|PRDATA[16]|PRDATA[17]|PRDATA[18]|PRDATA[19]|PRDATA[21]|PRDATA[23]|PRDATA[27]|PRDATA[28]|PRDATA[29]|PRDATA[31]|PRDATA[9]|PSLVERR|VGND
+ sky130_fd_pr__nfet_01v8 L=0.15 W=0.42 AS=0.10025 AD=0.1092 PS=0.985 PD=1.36
M$1143
+ LO|PRDATA[10]|PRDATA[12]|PRDATA[13]|PRDATA[15]|PRDATA[16]|PRDATA[17]|PRDATA[18]|PRDATA[19]|PRDATA[21]|PRDATA[23]|PRDATA[27]|PRDATA[28]|PRDATA[29]|PRDATA[31]|PRDATA[9]|PSLVERR|VGND
+ A|PADDR[4] B|B1|B_N|Y
+ LO|PRDATA[10]|PRDATA[12]|PRDATA[13]|PRDATA[15]|PRDATA[16]|PRDATA[17]|PRDATA[18]|PRDATA[19]|PRDATA[21]|PRDATA[23]|PRDATA[27]|PRDATA[28]|PRDATA[29]|PRDATA[31]|PRDATA[9]|PSLVERR|VGND
+ sky130_fd_pr__nfet_01v8 L=0.15 W=2.6 AS=0.43225 AD=0.351 PS=4.58 PD=3.68
M$1147
+ LO|PRDATA[10]|PRDATA[12]|PRDATA[13]|PRDATA[15]|PRDATA[16]|PRDATA[17]|PRDATA[18]|PRDATA[19]|PRDATA[21]|PRDATA[23]|PRDATA[27]|PRDATA[28]|PRDATA[29]|PRDATA[31]|PRDATA[9]|PSLVERR|VGND
+ B|PADDR[5] B|B1|B_N|Y
+ LO|PRDATA[10]|PRDATA[12]|PRDATA[13]|PRDATA[15]|PRDATA[16]|PRDATA[17]|PRDATA[18]|PRDATA[19]|PRDATA[21]|PRDATA[23]|PRDATA[27]|PRDATA[28]|PRDATA[29]|PRDATA[31]|PRDATA[9]|PSLVERR|VGND
+ sky130_fd_pr__nfet_01v8 L=0.15 W=2.6 AS=0.351 AD=0.52 PS=3.68 PD=4.2
M$1151
+ LO|PRDATA[10]|PRDATA[12]|PRDATA[13]|PRDATA[15]|PRDATA[16]|PRDATA[17]|PRDATA[18]|PRDATA[19]|PRDATA[21]|PRDATA[23]|PRDATA[27]|PRDATA[28]|PRDATA[29]|PRDATA[31]|PRDATA[9]|PSLVERR|VGND
+ C|C_N|D|D_N|PADDR[3] B|B1|B_N|Y
+ LO|PRDATA[10]|PRDATA[12]|PRDATA[13]|PRDATA[15]|PRDATA[16]|PRDATA[17]|PRDATA[18]|PRDATA[19]|PRDATA[21]|PRDATA[23]|PRDATA[27]|PRDATA[28]|PRDATA[29]|PRDATA[31]|PRDATA[9]|PSLVERR|VGND
+ sky130_fd_pr__nfet_01v8 L=0.15 W=2.6 AS=0.52 AD=0.351 PS=4.2 PD=3.68
M$1155
+ LO|PRDATA[10]|PRDATA[12]|PRDATA[13]|PRDATA[15]|PRDATA[16]|PRDATA[17]|PRDATA[18]|PRDATA[19]|PRDATA[21]|PRDATA[23]|PRDATA[27]|PRDATA[28]|PRDATA[29]|PRDATA[31]|PRDATA[9]|PSLVERR|VGND
+ \$539 B|B1|B_N|Y
+ LO|PRDATA[10]|PRDATA[12]|PRDATA[13]|PRDATA[15]|PRDATA[16]|PRDATA[17]|PRDATA[18]|PRDATA[19]|PRDATA[21]|PRDATA[23]|PRDATA[27]|PRDATA[28]|PRDATA[29]|PRDATA[31]|PRDATA[9]|PSLVERR|VGND
+ sky130_fd_pr__nfet_01v8 L=0.15 W=2.6 AS=0.351 AD=0.43225 PS=3.68 PD=4.58
M$1159 \$539 A|A2|C|D_N|X
+ LO|PRDATA[10]|PRDATA[12]|PRDATA[13]|PRDATA[15]|PRDATA[16]|PRDATA[17]|PRDATA[18]|PRDATA[19]|PRDATA[21]|PRDATA[23]|PRDATA[27]|PRDATA[28]|PRDATA[29]|PRDATA[31]|PRDATA[9]|PSLVERR|VGND
+ LO|PRDATA[10]|PRDATA[12]|PRDATA[13]|PRDATA[15]|PRDATA[16]|PRDATA[17]|PRDATA[18]|PRDATA[19]|PRDATA[21]|PRDATA[23]|PRDATA[27]|PRDATA[28]|PRDATA[29]|PRDATA[31]|PRDATA[9]|PSLVERR|VGND
+ sky130_fd_pr__nfet_01v8 L=0.15 W=0.65 AS=0.169 AD=0.182 PS=1.82 PD=1.86
M$1160
+ LO|PRDATA[10]|PRDATA[12]|PRDATA[13]|PRDATA[15]|PRDATA[16]|PRDATA[17]|PRDATA[18]|PRDATA[19]|PRDATA[21]|PRDATA[23]|PRDATA[27]|PRDATA[28]|PRDATA[29]|PRDATA[31]|PRDATA[9]|PSLVERR|VGND
+ A|X PRDATA[30]|Y
+ LO|PRDATA[10]|PRDATA[12]|PRDATA[13]|PRDATA[15]|PRDATA[16]|PRDATA[17]|PRDATA[18]|PRDATA[19]|PRDATA[21]|PRDATA[23]|PRDATA[27]|PRDATA[28]|PRDATA[29]|PRDATA[31]|PRDATA[9]|PSLVERR|VGND
+ sky130_fd_pr__nfet_01v8 L=0.15 W=1.3 AS=0.26975 AD=0.1755 PS=2.78 PD=1.84
M$1162
+ LO|PRDATA[10]|PRDATA[12]|PRDATA[13]|PRDATA[15]|PRDATA[16]|PRDATA[17]|PRDATA[18]|PRDATA[19]|PRDATA[21]|PRDATA[23]|PRDATA[27]|PRDATA[28]|PRDATA[29]|PRDATA[31]|PRDATA[9]|PSLVERR|VGND
+ B|Y PRDATA[30]|Y
+ LO|PRDATA[10]|PRDATA[12]|PRDATA[13]|PRDATA[15]|PRDATA[16]|PRDATA[17]|PRDATA[18]|PRDATA[19]|PRDATA[21]|PRDATA[23]|PRDATA[27]|PRDATA[28]|PRDATA[29]|PRDATA[31]|PRDATA[9]|PSLVERR|VGND
+ sky130_fd_pr__nfet_01v8 L=0.15 W=1.3 AS=0.1755 AD=0.25675 PS=1.84 PD=2.74
M$1164
+ LO|PRDATA[10]|PRDATA[12]|PRDATA[13]|PRDATA[15]|PRDATA[16]|PRDATA[17]|PRDATA[18]|PRDATA[19]|PRDATA[21]|PRDATA[23]|PRDATA[27]|PRDATA[28]|PRDATA[29]|PRDATA[31]|PRDATA[9]|PSLVERR|VGND
+ A|X PRDATA[20]|Y
+ LO|PRDATA[10]|PRDATA[12]|PRDATA[13]|PRDATA[15]|PRDATA[16]|PRDATA[17]|PRDATA[18]|PRDATA[19]|PRDATA[21]|PRDATA[23]|PRDATA[27]|PRDATA[28]|PRDATA[29]|PRDATA[31]|PRDATA[9]|PSLVERR|VGND
+ sky130_fd_pr__nfet_01v8 L=0.15 W=1.3 AS=0.26975 AD=0.1755 PS=2.78 PD=1.84
M$1166
+ LO|PRDATA[10]|PRDATA[12]|PRDATA[13]|PRDATA[15]|PRDATA[16]|PRDATA[17]|PRDATA[18]|PRDATA[19]|PRDATA[21]|PRDATA[23]|PRDATA[27]|PRDATA[28]|PRDATA[29]|PRDATA[31]|PRDATA[9]|PSLVERR|VGND
+ B|Y PRDATA[20]|Y
+ LO|PRDATA[10]|PRDATA[12]|PRDATA[13]|PRDATA[15]|PRDATA[16]|PRDATA[17]|PRDATA[18]|PRDATA[19]|PRDATA[21]|PRDATA[23]|PRDATA[27]|PRDATA[28]|PRDATA[29]|PRDATA[31]|PRDATA[9]|PSLVERR|VGND
+ sky130_fd_pr__nfet_01v8 L=0.15 W=1.3 AS=0.1755 AD=0.25675 PS=1.84 PD=2.74
M$1168 \$608 S|X
+ LO|PRDATA[10]|PRDATA[12]|PRDATA[13]|PRDATA[15]|PRDATA[16]|PRDATA[17]|PRDATA[18]|PRDATA[19]|PRDATA[21]|PRDATA[23]|PRDATA[27]|PRDATA[28]|PRDATA[29]|PRDATA[31]|PRDATA[9]|PSLVERR|VGND
+ LO|PRDATA[10]|PRDATA[12]|PRDATA[13]|PRDATA[15]|PRDATA[16]|PRDATA[17]|PRDATA[18]|PRDATA[19]|PRDATA[21]|PRDATA[23]|PRDATA[27]|PRDATA[28]|PRDATA[29]|PRDATA[31]|PRDATA[9]|PSLVERR|VGND
+ sky130_fd_pr__nfet_01v8 L=0.15 W=0.65 AS=0.169 AD=0.108875 PS=1.82 PD=0.985
M$1169
+ LO|PRDATA[10]|PRDATA[12]|PRDATA[13]|PRDATA[15]|PRDATA[16]|PRDATA[17]|PRDATA[18]|PRDATA[19]|PRDATA[21]|PRDATA[23]|PRDATA[27]|PRDATA[28]|PRDATA[29]|PRDATA[31]|PRDATA[9]|PSLVERR|VGND
+ \$608 \$632
+ LO|PRDATA[10]|PRDATA[12]|PRDATA[13]|PRDATA[15]|PRDATA[16]|PRDATA[17]|PRDATA[18]|PRDATA[19]|PRDATA[21]|PRDATA[23]|PRDATA[27]|PRDATA[28]|PRDATA[29]|PRDATA[31]|PRDATA[9]|PSLVERR|VGND
+ sky130_fd_pr__nfet_01v8 L=0.15 W=0.65 AS=0.108875 AD=0.26 PS=0.985 PD=1.45
M$1170 \$632 A0|A1|Q|gpio_out[2] \$611
+ LO|PRDATA[10]|PRDATA[12]|PRDATA[13]|PRDATA[15]|PRDATA[16]|PRDATA[17]|PRDATA[18]|PRDATA[19]|PRDATA[21]|PRDATA[23]|PRDATA[27]|PRDATA[28]|PRDATA[29]|PRDATA[31]|PRDATA[9]|PSLVERR|VGND
+ sky130_fd_pr__nfet_01v8 L=0.15 W=0.65 AS=0.26 AD=0.104 PS=1.45 PD=0.97
M$1171 \$611 A1|PWDATA[2] \$633
+ LO|PRDATA[10]|PRDATA[12]|PRDATA[13]|PRDATA[15]|PRDATA[16]|PRDATA[17]|PRDATA[18]|PRDATA[19]|PRDATA[21]|PRDATA[23]|PRDATA[27]|PRDATA[28]|PRDATA[29]|PRDATA[31]|PRDATA[9]|PSLVERR|VGND
+ sky130_fd_pr__nfet_01v8 L=0.15 W=0.65 AS=0.104 AD=0.274625 PS=0.97 PD=1.495
M$1172 \$633 S|X
+ LO|PRDATA[10]|PRDATA[12]|PRDATA[13]|PRDATA[15]|PRDATA[16]|PRDATA[17]|PRDATA[18]|PRDATA[19]|PRDATA[21]|PRDATA[23]|PRDATA[27]|PRDATA[28]|PRDATA[29]|PRDATA[31]|PRDATA[9]|PSLVERR|VGND
+ LO|PRDATA[10]|PRDATA[12]|PRDATA[13]|PRDATA[15]|PRDATA[16]|PRDATA[17]|PRDATA[18]|PRDATA[19]|PRDATA[21]|PRDATA[23]|PRDATA[27]|PRDATA[28]|PRDATA[29]|PRDATA[31]|PRDATA[9]|PSLVERR|VGND
+ sky130_fd_pr__nfet_01v8 L=0.15 W=0.65 AS=0.274625 AD=0.08775 PS=1.495 PD=0.92
M$1173
+ LO|PRDATA[10]|PRDATA[12]|PRDATA[13]|PRDATA[15]|PRDATA[16]|PRDATA[17]|PRDATA[18]|PRDATA[19]|PRDATA[21]|PRDATA[23]|PRDATA[27]|PRDATA[28]|PRDATA[29]|PRDATA[31]|PRDATA[9]|PSLVERR|VGND
+ \$611 A|X
+ LO|PRDATA[10]|PRDATA[12]|PRDATA[13]|PRDATA[15]|PRDATA[16]|PRDATA[17]|PRDATA[18]|PRDATA[19]|PRDATA[21]|PRDATA[23]|PRDATA[27]|PRDATA[28]|PRDATA[29]|PRDATA[31]|PRDATA[9]|PSLVERR|VGND
+ sky130_fd_pr__nfet_01v8 L=0.15 W=2.6 AS=0.351 AD=0.43225 PS=3.68 PD=4.58
M$1177
+ LO|PRDATA[10]|PRDATA[12]|PRDATA[13]|PRDATA[15]|PRDATA[16]|PRDATA[17]|PRDATA[18]|PRDATA[19]|PRDATA[21]|PRDATA[23]|PRDATA[27]|PRDATA[28]|PRDATA[29]|PRDATA[31]|PRDATA[9]|PSLVERR|VGND
+ S|X \$653
+ LO|PRDATA[10]|PRDATA[12]|PRDATA[13]|PRDATA[15]|PRDATA[16]|PRDATA[17]|PRDATA[18]|PRDATA[19]|PRDATA[21]|PRDATA[23]|PRDATA[27]|PRDATA[28]|PRDATA[29]|PRDATA[31]|PRDATA[9]|PSLVERR|VGND
+ sky130_fd_pr__nfet_01v8 L=0.15 W=0.42 AS=0.11285 AD=0.0693 PS=1.045 PD=0.75
M$1178 \$653 A1|PWDATA[2] \$639
+ LO|PRDATA[10]|PRDATA[12]|PRDATA[13]|PRDATA[15]|PRDATA[16]|PRDATA[17]|PRDATA[18]|PRDATA[19]|PRDATA[21]|PRDATA[23]|PRDATA[27]|PRDATA[28]|PRDATA[29]|PRDATA[31]|PRDATA[9]|PSLVERR|VGND
+ sky130_fd_pr__nfet_01v8 L=0.15 W=0.42 AS=0.0693 AD=0.09975 PS=0.75 PD=0.895
M$1179 \$639 A0|B2|Q|gpio_oe[2] \$655
+ LO|PRDATA[10]|PRDATA[12]|PRDATA[13]|PRDATA[15]|PRDATA[16]|PRDATA[17]|PRDATA[18]|PRDATA[19]|PRDATA[21]|PRDATA[23]|PRDATA[27]|PRDATA[28]|PRDATA[29]|PRDATA[31]|PRDATA[9]|PSLVERR|VGND
+ sky130_fd_pr__nfet_01v8 L=0.15 W=0.42 AS=0.09975 AD=0.0693 PS=0.895 PD=0.75
M$1180 \$655 \$640
+ LO|PRDATA[10]|PRDATA[12]|PRDATA[13]|PRDATA[15]|PRDATA[16]|PRDATA[17]|PRDATA[18]|PRDATA[19]|PRDATA[21]|PRDATA[23]|PRDATA[27]|PRDATA[28]|PRDATA[29]|PRDATA[31]|PRDATA[9]|PSLVERR|VGND
+ LO|PRDATA[10]|PRDATA[12]|PRDATA[13]|PRDATA[15]|PRDATA[16]|PRDATA[17]|PRDATA[18]|PRDATA[19]|PRDATA[21]|PRDATA[23]|PRDATA[27]|PRDATA[28]|PRDATA[29]|PRDATA[31]|PRDATA[9]|PSLVERR|VGND
+ sky130_fd_pr__nfet_01v8 L=0.15 W=0.42 AS=0.0693 AD=0.1449 PS=0.75 PD=1.11
M$1181
+ LO|PRDATA[10]|PRDATA[12]|PRDATA[13]|PRDATA[15]|PRDATA[16]|PRDATA[17]|PRDATA[18]|PRDATA[19]|PRDATA[21]|PRDATA[23]|PRDATA[27]|PRDATA[28]|PRDATA[29]|PRDATA[31]|PRDATA[9]|PSLVERR|VGND
+ S|X \$640
+ LO|PRDATA[10]|PRDATA[12]|PRDATA[13]|PRDATA[15]|PRDATA[16]|PRDATA[17]|PRDATA[18]|PRDATA[19]|PRDATA[21]|PRDATA[23]|PRDATA[27]|PRDATA[28]|PRDATA[29]|PRDATA[31]|PRDATA[9]|PSLVERR|VGND
+ sky130_fd_pr__nfet_01v8 L=0.15 W=0.42 AS=0.1449 AD=0.1092 PS=1.11 PD=1.36
M$1182 A|X \$639
+ LO|PRDATA[10]|PRDATA[12]|PRDATA[13]|PRDATA[15]|PRDATA[16]|PRDATA[17]|PRDATA[18]|PRDATA[19]|PRDATA[21]|PRDATA[23]|PRDATA[27]|PRDATA[28]|PRDATA[29]|PRDATA[31]|PRDATA[9]|PSLVERR|VGND
+ LO|PRDATA[10]|PRDATA[12]|PRDATA[13]|PRDATA[15]|PRDATA[16]|PRDATA[17]|PRDATA[18]|PRDATA[19]|PRDATA[21]|PRDATA[23]|PRDATA[27]|PRDATA[28]|PRDATA[29]|PRDATA[31]|PRDATA[9]|PSLVERR|VGND
+ sky130_fd_pr__nfet_01v8 L=0.15 W=0.65 AS=0.169 AD=0.11285 PS=1.82 PD=1.045
M$1183
+ LO|PRDATA[10]|PRDATA[12]|PRDATA[13]|PRDATA[15]|PRDATA[16]|PRDATA[17]|PRDATA[18]|PRDATA[19]|PRDATA[21]|PRDATA[23]|PRDATA[27]|PRDATA[28]|PRDATA[29]|PRDATA[31]|PRDATA[9]|PSLVERR|VGND
+ A|X \$641
+ LO|PRDATA[10]|PRDATA[12]|PRDATA[13]|PRDATA[15]|PRDATA[16]|PRDATA[17]|PRDATA[18]|PRDATA[19]|PRDATA[21]|PRDATA[23]|PRDATA[27]|PRDATA[28]|PRDATA[29]|PRDATA[31]|PRDATA[9]|PSLVERR|VGND
+ sky130_fd_pr__nfet_01v8 L=0.15 W=1.3 AS=0.25675 AD=0.1755 PS=2.74 PD=1.84
M$1185
+ LO|PRDATA[10]|PRDATA[12]|PRDATA[13]|PRDATA[15]|PRDATA[16]|PRDATA[17]|PRDATA[18]|PRDATA[19]|PRDATA[21]|PRDATA[23]|PRDATA[27]|PRDATA[28]|PRDATA[29]|PRDATA[31]|PRDATA[9]|PSLVERR|VGND
+ \$641 D|X
+ LO|PRDATA[10]|PRDATA[12]|PRDATA[13]|PRDATA[15]|PRDATA[16]|PRDATA[17]|PRDATA[18]|PRDATA[19]|PRDATA[21]|PRDATA[23]|PRDATA[27]|PRDATA[28]|PRDATA[29]|PRDATA[31]|PRDATA[9]|PSLVERR|VGND
+ sky130_fd_pr__nfet_01v8 L=0.15 W=3.9 AS=0.5265 AD=0.60775 PS=5.52 PD=6.42
M$1191 \$613 CLK|X
+ LO|PRDATA[10]|PRDATA[12]|PRDATA[13]|PRDATA[15]|PRDATA[16]|PRDATA[17]|PRDATA[18]|PRDATA[19]|PRDATA[21]|PRDATA[23]|PRDATA[27]|PRDATA[28]|PRDATA[29]|PRDATA[31]|PRDATA[9]|PSLVERR|VGND
+ LO|PRDATA[10]|PRDATA[12]|PRDATA[13]|PRDATA[15]|PRDATA[16]|PRDATA[17]|PRDATA[18]|PRDATA[19]|PRDATA[21]|PRDATA[23]|PRDATA[27]|PRDATA[28]|PRDATA[29]|PRDATA[31]|PRDATA[9]|PSLVERR|VGND
+ sky130_fd_pr__nfet_01v8 L=0.15 W=0.42 AS=0.1092 AD=0.0567 PS=1.36 PD=0.69
M$1192
+ LO|PRDATA[10]|PRDATA[12]|PRDATA[13]|PRDATA[15]|PRDATA[16]|PRDATA[17]|PRDATA[18]|PRDATA[19]|PRDATA[21]|PRDATA[23]|PRDATA[27]|PRDATA[28]|PRDATA[29]|PRDATA[31]|PRDATA[9]|PSLVERR|VGND
+ \$613 \$614
+ LO|PRDATA[10]|PRDATA[12]|PRDATA[13]|PRDATA[15]|PRDATA[16]|PRDATA[17]|PRDATA[18]|PRDATA[19]|PRDATA[21]|PRDATA[23]|PRDATA[27]|PRDATA[28]|PRDATA[29]|PRDATA[31]|PRDATA[9]|PSLVERR|VGND
+ sky130_fd_pr__nfet_01v8 L=0.15 W=0.42 AS=0.0567 AD=0.1092 PS=0.69 PD=1.36
M$1193
+ LO|PRDATA[10]|PRDATA[12]|PRDATA[13]|PRDATA[15]|PRDATA[16]|PRDATA[17]|PRDATA[18]|PRDATA[19]|PRDATA[21]|PRDATA[23]|PRDATA[27]|PRDATA[28]|PRDATA[29]|PRDATA[31]|PRDATA[9]|PSLVERR|VGND
+ D|X \$616
+ LO|PRDATA[10]|PRDATA[12]|PRDATA[13]|PRDATA[15]|PRDATA[16]|PRDATA[17]|PRDATA[18]|PRDATA[19]|PRDATA[21]|PRDATA[23]|PRDATA[27]|PRDATA[28]|PRDATA[29]|PRDATA[31]|PRDATA[9]|PSLVERR|VGND
+ sky130_fd_pr__nfet_01v8 L=0.15 W=0.42 AS=0.2205 AD=0.066 PS=1.89 PD=0.745
M$1194 \$616 \$613 \$617
+ LO|PRDATA[10]|PRDATA[12]|PRDATA[13]|PRDATA[15]|PRDATA[16]|PRDATA[17]|PRDATA[18]|PRDATA[19]|PRDATA[21]|PRDATA[23]|PRDATA[27]|PRDATA[28]|PRDATA[29]|PRDATA[31]|PRDATA[9]|PSLVERR|VGND
+ sky130_fd_pr__nfet_01v8 L=0.15 W=0.36 AS=0.066 AD=0.0594 PS=0.745 PD=0.69
M$1195 \$635 \$614 \$617
+ LO|PRDATA[10]|PRDATA[12]|PRDATA[13]|PRDATA[15]|PRDATA[16]|PRDATA[17]|PRDATA[18]|PRDATA[19]|PRDATA[21]|PRDATA[23]|PRDATA[27]|PRDATA[28]|PRDATA[29]|PRDATA[31]|PRDATA[9]|PSLVERR|VGND
+ sky130_fd_pr__nfet_01v8 L=0.15 W=0.36 AS=0.1401 AD=0.0594 PS=1.1 PD=0.69
M$1196 \$635 \$619 \$636
+ LO|PRDATA[10]|PRDATA[12]|PRDATA[13]|PRDATA[15]|PRDATA[16]|PRDATA[17]|PRDATA[18]|PRDATA[19]|PRDATA[21]|PRDATA[23]|PRDATA[27]|PRDATA[28]|PRDATA[29]|PRDATA[31]|PRDATA[9]|PSLVERR|VGND
+ sky130_fd_pr__nfet_01v8 L=0.15 W=0.42 AS=0.1401 AD=0.0441 PS=1.1 PD=0.63
M$1197
+ LO|PRDATA[10]|PRDATA[12]|PRDATA[13]|PRDATA[15]|PRDATA[16]|PRDATA[17]|PRDATA[18]|PRDATA[19]|PRDATA[21]|PRDATA[23]|PRDATA[27]|PRDATA[28]|PRDATA[29]|PRDATA[31]|PRDATA[9]|PSLVERR|VGND
+ PRESETn|RESET_B \$636
+ LO|PRDATA[10]|PRDATA[12]|PRDATA[13]|PRDATA[15]|PRDATA[16]|PRDATA[17]|PRDATA[18]|PRDATA[19]|PRDATA[21]|PRDATA[23]|PRDATA[27]|PRDATA[28]|PRDATA[29]|PRDATA[31]|PRDATA[9]|PSLVERR|VGND
+ sky130_fd_pr__nfet_01v8 L=0.15 W=0.42 AS=0.1346 AD=0.0441 PS=1.15 PD=0.63
M$1198
+ LO|PRDATA[10]|PRDATA[12]|PRDATA[13]|PRDATA[15]|PRDATA[16]|PRDATA[17]|PRDATA[18]|PRDATA[19]|PRDATA[21]|PRDATA[23]|PRDATA[27]|PRDATA[28]|PRDATA[29]|PRDATA[31]|PRDATA[9]|PSLVERR|VGND
+ \$617 \$619
+ LO|PRDATA[10]|PRDATA[12]|PRDATA[13]|PRDATA[15]|PRDATA[16]|PRDATA[17]|PRDATA[18]|PRDATA[19]|PRDATA[21]|PRDATA[23]|PRDATA[27]|PRDATA[28]|PRDATA[29]|PRDATA[31]|PRDATA[9]|PSLVERR|VGND
+ sky130_fd_pr__nfet_01v8 L=0.15 W=0.64 AS=0.1346 AD=0.0999 PS=1.15 PD=0.985
M$1199 \$619 \$614 \$620
+ LO|PRDATA[10]|PRDATA[12]|PRDATA[13]|PRDATA[15]|PRDATA[16]|PRDATA[17]|PRDATA[18]|PRDATA[19]|PRDATA[21]|PRDATA[23]|PRDATA[27]|PRDATA[28]|PRDATA[29]|PRDATA[31]|PRDATA[9]|PSLVERR|VGND
+ sky130_fd_pr__nfet_01v8 L=0.15 W=0.36 AS=0.0999 AD=0.0711 PS=0.985 PD=0.755
M$1200 \$637 \$613 \$620
+ LO|PRDATA[10]|PRDATA[12]|PRDATA[13]|PRDATA[15]|PRDATA[16]|PRDATA[17]|PRDATA[18]|PRDATA[19]|PRDATA[21]|PRDATA[23]|PRDATA[27]|PRDATA[28]|PRDATA[29]|PRDATA[31]|PRDATA[9]|PSLVERR|VGND
+ sky130_fd_pr__nfet_01v8 L=0.15 W=0.36 AS=0.0669 AD=0.0711 PS=0.75 PD=0.755
M$1201 \$637 \$621
+ LO|PRDATA[10]|PRDATA[12]|PRDATA[13]|PRDATA[15]|PRDATA[16]|PRDATA[17]|PRDATA[18]|PRDATA[19]|PRDATA[21]|PRDATA[23]|PRDATA[27]|PRDATA[28]|PRDATA[29]|PRDATA[31]|PRDATA[9]|PSLVERR|VGND
+ LO|PRDATA[10]|PRDATA[12]|PRDATA[13]|PRDATA[15]|PRDATA[16]|PRDATA[17]|PRDATA[18]|PRDATA[19]|PRDATA[21]|PRDATA[23]|PRDATA[27]|PRDATA[28]|PRDATA[29]|PRDATA[31]|PRDATA[9]|PSLVERR|VGND
+ sky130_fd_pr__nfet_01v8 L=0.15 W=0.42 AS=0.0669 AD=0.12495 PS=0.75 PD=1.015
M$1202
+ LO|PRDATA[10]|PRDATA[12]|PRDATA[13]|PRDATA[15]|PRDATA[16]|PRDATA[17]|PRDATA[18]|PRDATA[19]|PRDATA[21]|PRDATA[23]|PRDATA[27]|PRDATA[28]|PRDATA[29]|PRDATA[31]|PRDATA[9]|PSLVERR|VGND
+ PRESETn|RESET_B \$638
+ LO|PRDATA[10]|PRDATA[12]|PRDATA[13]|PRDATA[15]|PRDATA[16]|PRDATA[17]|PRDATA[18]|PRDATA[19]|PRDATA[21]|PRDATA[23]|PRDATA[27]|PRDATA[28]|PRDATA[29]|PRDATA[31]|PRDATA[9]|PSLVERR|VGND
+ sky130_fd_pr__nfet_01v8 L=0.15 W=0.42 AS=0.12495 AD=0.06405 PS=1.015 PD=0.725
M$1203 \$638 \$620 \$621
+ LO|PRDATA[10]|PRDATA[12]|PRDATA[13]|PRDATA[15]|PRDATA[16]|PRDATA[17]|PRDATA[18]|PRDATA[19]|PRDATA[21]|PRDATA[23]|PRDATA[27]|PRDATA[28]|PRDATA[29]|PRDATA[31]|PRDATA[9]|PSLVERR|VGND
+ sky130_fd_pr__nfet_01v8 L=0.15 W=0.42 AS=0.06405 AD=0.1092 PS=0.725 PD=1.36
M$1204
+ LO|PRDATA[10]|PRDATA[12]|PRDATA[13]|PRDATA[15]|PRDATA[16]|PRDATA[17]|PRDATA[18]|PRDATA[19]|PRDATA[21]|PRDATA[23]|PRDATA[27]|PRDATA[28]|PRDATA[29]|PRDATA[31]|PRDATA[9]|PSLVERR|VGND
+ \$621 A0|A1|Q|gpio_out[2]
+ LO|PRDATA[10]|PRDATA[12]|PRDATA[13]|PRDATA[15]|PRDATA[16]|PRDATA[17]|PRDATA[18]|PRDATA[19]|PRDATA[21]|PRDATA[23]|PRDATA[27]|PRDATA[28]|PRDATA[29]|PRDATA[31]|PRDATA[9]|PSLVERR|VGND
+ sky130_fd_pr__nfet_01v8 L=0.15 W=0.65 AS=0.2087 AD=0.169 PS=2.02 PD=1.82
M$1205
+ LO|PRDATA[10]|PRDATA[12]|PRDATA[13]|PRDATA[15]|PRDATA[16]|PRDATA[17]|PRDATA[18]|PRDATA[19]|PRDATA[21]|PRDATA[23]|PRDATA[27]|PRDATA[28]|PRDATA[29]|PRDATA[31]|PRDATA[9]|PSLVERR|VGND
+ A|X \$643
+ LO|PRDATA[10]|PRDATA[12]|PRDATA[13]|PRDATA[15]|PRDATA[16]|PRDATA[17]|PRDATA[18]|PRDATA[19]|PRDATA[21]|PRDATA[23]|PRDATA[27]|PRDATA[28]|PRDATA[29]|PRDATA[31]|PRDATA[9]|PSLVERR|VGND
+ sky130_fd_pr__nfet_01v8 L=0.15 W=1.3 AS=0.25675 AD=0.1755 PS=2.74 PD=1.84
M$1207
+ LO|PRDATA[10]|PRDATA[12]|PRDATA[13]|PRDATA[15]|PRDATA[16]|PRDATA[17]|PRDATA[18]|PRDATA[19]|PRDATA[21]|PRDATA[23]|PRDATA[27]|PRDATA[28]|PRDATA[29]|PRDATA[31]|PRDATA[9]|PSLVERR|VGND
+ \$643 D|X
+ LO|PRDATA[10]|PRDATA[12]|PRDATA[13]|PRDATA[15]|PRDATA[16]|PRDATA[17]|PRDATA[18]|PRDATA[19]|PRDATA[21]|PRDATA[23]|PRDATA[27]|PRDATA[28]|PRDATA[29]|PRDATA[31]|PRDATA[9]|PSLVERR|VGND
+ sky130_fd_pr__nfet_01v8 L=0.15 W=3.9 AS=0.5265 AD=0.60775 PS=5.52 PD=6.42
M$1213
+ LO|PRDATA[10]|PRDATA[12]|PRDATA[13]|PRDATA[15]|PRDATA[16]|PRDATA[17]|PRDATA[18]|PRDATA[19]|PRDATA[21]|PRDATA[23]|PRDATA[27]|PRDATA[28]|PRDATA[29]|PRDATA[31]|PRDATA[9]|PSLVERR|VGND
+ A|B1|X \$622
+ LO|PRDATA[10]|PRDATA[12]|PRDATA[13]|PRDATA[15]|PRDATA[16]|PRDATA[17]|PRDATA[18]|PRDATA[19]|PRDATA[21]|PRDATA[23]|PRDATA[27]|PRDATA[28]|PRDATA[29]|PRDATA[31]|PRDATA[9]|PSLVERR|VGND
+ sky130_fd_pr__nfet_01v8 L=0.15 W=0.42 AS=0.097 AD=0.1092 PS=0.975 PD=1.36
M$1214
+ LO|PRDATA[10]|PRDATA[12]|PRDATA[13]|PRDATA[15]|PRDATA[16]|PRDATA[17]|PRDATA[18]|PRDATA[19]|PRDATA[21]|PRDATA[23]|PRDATA[27]|PRDATA[28]|PRDATA[29]|PRDATA[31]|PRDATA[9]|PSLVERR|VGND
+ \$622 A|X
+ LO|PRDATA[10]|PRDATA[12]|PRDATA[13]|PRDATA[15]|PRDATA[16]|PRDATA[17]|PRDATA[18]|PRDATA[19]|PRDATA[21]|PRDATA[23]|PRDATA[27]|PRDATA[28]|PRDATA[29]|PRDATA[31]|PRDATA[9]|PSLVERR|VGND
+ sky130_fd_pr__nfet_01v8 L=0.15 W=1.3 AS=0.18475 AD=0.26 PS=1.895 PD=2.75
M$1216
+ LO|PRDATA[10]|PRDATA[12]|PRDATA[13]|PRDATA[15]|PRDATA[16]|PRDATA[17]|PRDATA[18]|PRDATA[19]|PRDATA[21]|PRDATA[23]|PRDATA[27]|PRDATA[28]|PRDATA[29]|PRDATA[31]|PRDATA[9]|PSLVERR|VGND
+ A|PADDR[4] B|B1|Y
+ LO|PRDATA[10]|PRDATA[12]|PRDATA[13]|PRDATA[15]|PRDATA[16]|PRDATA[17]|PRDATA[18]|PRDATA[19]|PRDATA[21]|PRDATA[23]|PRDATA[27]|PRDATA[28]|PRDATA[29]|PRDATA[31]|PRDATA[9]|PSLVERR|VGND
+ sky130_fd_pr__nfet_01v8 L=0.15 W=1.3 AS=0.26975 AD=0.1755 PS=2.78 PD=1.84
M$1218
+ LO|PRDATA[10]|PRDATA[12]|PRDATA[13]|PRDATA[15]|PRDATA[16]|PRDATA[17]|PRDATA[18]|PRDATA[19]|PRDATA[21]|PRDATA[23]|PRDATA[27]|PRDATA[28]|PRDATA[29]|PRDATA[31]|PRDATA[9]|PSLVERR|VGND
+ B|PADDR[5] B|B1|Y
+ LO|PRDATA[10]|PRDATA[12]|PRDATA[13]|PRDATA[15]|PRDATA[16]|PRDATA[17]|PRDATA[18]|PRDATA[19]|PRDATA[21]|PRDATA[23]|PRDATA[27]|PRDATA[28]|PRDATA[29]|PRDATA[31]|PRDATA[9]|PSLVERR|VGND
+ sky130_fd_pr__nfet_01v8 L=0.15 W=1.3 AS=0.1755 AD=0.25675 PS=1.84 PD=2.74
M$1220
+ LO|PRDATA[10]|PRDATA[12]|PRDATA[13]|PRDATA[15]|PRDATA[16]|PRDATA[17]|PRDATA[18]|PRDATA[19]|PRDATA[21]|PRDATA[23]|PRDATA[27]|PRDATA[28]|PRDATA[29]|PRDATA[31]|PRDATA[9]|PSLVERR|VGND
+ \$625 B|B1|Y
+ LO|PRDATA[10]|PRDATA[12]|PRDATA[13]|PRDATA[15]|PRDATA[16]|PRDATA[17]|PRDATA[18]|PRDATA[19]|PRDATA[21]|PRDATA[23]|PRDATA[27]|PRDATA[28]|PRDATA[29]|PRDATA[31]|PRDATA[9]|PSLVERR|VGND
+ sky130_fd_pr__nfet_01v8 L=0.15 W=1.3 AS=0.25675 AD=0.26975 PS=2.74 PD=2.78
M$1222 \$625 C|C_N|D|D_N|PADDR[3]
+ LO|PRDATA[10]|PRDATA[12]|PRDATA[13]|PRDATA[15]|PRDATA[16]|PRDATA[17]|PRDATA[18]|PRDATA[19]|PRDATA[21]|PRDATA[23]|PRDATA[27]|PRDATA[28]|PRDATA[29]|PRDATA[31]|PRDATA[9]|PSLVERR|VGND
+ LO|PRDATA[10]|PRDATA[12]|PRDATA[13]|PRDATA[15]|PRDATA[16]|PRDATA[17]|PRDATA[18]|PRDATA[19]|PRDATA[21]|PRDATA[23]|PRDATA[27]|PRDATA[28]|PRDATA[29]|PRDATA[31]|PRDATA[9]|PSLVERR|VGND
+ sky130_fd_pr__nfet_01v8 L=0.15 W=0.42 AS=0.1092 AD=0.1092 PS=1.36 PD=1.36
M$1223
+ LO|PRDATA[10]|PRDATA[12]|PRDATA[13]|PRDATA[15]|PRDATA[16]|PRDATA[17]|PRDATA[18]|PRDATA[19]|PRDATA[21]|PRDATA[23]|PRDATA[27]|PRDATA[28]|PRDATA[29]|PRDATA[31]|PRDATA[9]|PSLVERR|VGND
+ A|X PRDATA[26]|Y
+ LO|PRDATA[10]|PRDATA[12]|PRDATA[13]|PRDATA[15]|PRDATA[16]|PRDATA[17]|PRDATA[18]|PRDATA[19]|PRDATA[21]|PRDATA[23]|PRDATA[27]|PRDATA[28]|PRDATA[29]|PRDATA[31]|PRDATA[9]|PSLVERR|VGND
+ sky130_fd_pr__nfet_01v8 L=0.15 W=1.3 AS=0.26975 AD=0.1755 PS=2.78 PD=1.84
M$1225
+ LO|PRDATA[10]|PRDATA[12]|PRDATA[13]|PRDATA[15]|PRDATA[16]|PRDATA[17]|PRDATA[18]|PRDATA[19]|PRDATA[21]|PRDATA[23]|PRDATA[27]|PRDATA[28]|PRDATA[29]|PRDATA[31]|PRDATA[9]|PSLVERR|VGND
+ B|Y PRDATA[26]|Y
+ LO|PRDATA[10]|PRDATA[12]|PRDATA[13]|PRDATA[15]|PRDATA[16]|PRDATA[17]|PRDATA[18]|PRDATA[19]|PRDATA[21]|PRDATA[23]|PRDATA[27]|PRDATA[28]|PRDATA[29]|PRDATA[31]|PRDATA[9]|PSLVERR|VGND
+ sky130_fd_pr__nfet_01v8 L=0.15 W=1.3 AS=0.1755 AD=0.25675 PS=1.84 PD=2.74
M$1227
+ LO|PRDATA[10]|PRDATA[12]|PRDATA[13]|PRDATA[15]|PRDATA[16]|PRDATA[17]|PRDATA[18]|PRDATA[19]|PRDATA[21]|PRDATA[23]|PRDATA[27]|PRDATA[28]|PRDATA[29]|PRDATA[31]|PRDATA[9]|PSLVERR|VGND
+ A|X PRDATA[24]|Y
+ LO|PRDATA[10]|PRDATA[12]|PRDATA[13]|PRDATA[15]|PRDATA[16]|PRDATA[17]|PRDATA[18]|PRDATA[19]|PRDATA[21]|PRDATA[23]|PRDATA[27]|PRDATA[28]|PRDATA[29]|PRDATA[31]|PRDATA[9]|PSLVERR|VGND
+ sky130_fd_pr__nfet_01v8 L=0.15 W=1.3 AS=0.26975 AD=0.1755 PS=2.78 PD=1.84
M$1229
+ LO|PRDATA[10]|PRDATA[12]|PRDATA[13]|PRDATA[15]|PRDATA[16]|PRDATA[17]|PRDATA[18]|PRDATA[19]|PRDATA[21]|PRDATA[23]|PRDATA[27]|PRDATA[28]|PRDATA[29]|PRDATA[31]|PRDATA[9]|PSLVERR|VGND
+ B|Y PRDATA[24]|Y
+ LO|PRDATA[10]|PRDATA[12]|PRDATA[13]|PRDATA[15]|PRDATA[16]|PRDATA[17]|PRDATA[18]|PRDATA[19]|PRDATA[21]|PRDATA[23]|PRDATA[27]|PRDATA[28]|PRDATA[29]|PRDATA[31]|PRDATA[9]|PSLVERR|VGND
+ sky130_fd_pr__nfet_01v8 L=0.15 W=1.3 AS=0.1755 AD=0.25675 PS=1.84 PD=2.74
M$1231
+ LO|PRDATA[10]|PRDATA[12]|PRDATA[13]|PRDATA[15]|PRDATA[16]|PRDATA[17]|PRDATA[18]|PRDATA[19]|PRDATA[21]|PRDATA[23]|PRDATA[27]|PRDATA[28]|PRDATA[29]|PRDATA[31]|PRDATA[9]|PSLVERR|VGND
+ A|X PRDATA[25]|Y
+ LO|PRDATA[10]|PRDATA[12]|PRDATA[13]|PRDATA[15]|PRDATA[16]|PRDATA[17]|PRDATA[18]|PRDATA[19]|PRDATA[21]|PRDATA[23]|PRDATA[27]|PRDATA[28]|PRDATA[29]|PRDATA[31]|PRDATA[9]|PSLVERR|VGND
+ sky130_fd_pr__nfet_01v8 L=0.15 W=1.3 AS=0.26975 AD=0.1755 PS=2.78 PD=1.84
M$1233
+ LO|PRDATA[10]|PRDATA[12]|PRDATA[13]|PRDATA[15]|PRDATA[16]|PRDATA[17]|PRDATA[18]|PRDATA[19]|PRDATA[21]|PRDATA[23]|PRDATA[27]|PRDATA[28]|PRDATA[29]|PRDATA[31]|PRDATA[9]|PSLVERR|VGND
+ B|Y PRDATA[25]|Y
+ LO|PRDATA[10]|PRDATA[12]|PRDATA[13]|PRDATA[15]|PRDATA[16]|PRDATA[17]|PRDATA[18]|PRDATA[19]|PRDATA[21]|PRDATA[23]|PRDATA[27]|PRDATA[28]|PRDATA[29]|PRDATA[31]|PRDATA[9]|PSLVERR|VGND
+ sky130_fd_pr__nfet_01v8 L=0.15 W=1.3 AS=0.1755 AD=0.25675 PS=1.84 PD=2.74
M$1235
+ LO|PRDATA[10]|PRDATA[12]|PRDATA[13]|PRDATA[15]|PRDATA[16]|PRDATA[17]|PRDATA[18]|PRDATA[19]|PRDATA[21]|PRDATA[23]|PRDATA[27]|PRDATA[28]|PRDATA[29]|PRDATA[31]|PRDATA[9]|PSLVERR|VGND
+ A|X PRDATA[22]|Y
+ LO|PRDATA[10]|PRDATA[12]|PRDATA[13]|PRDATA[15]|PRDATA[16]|PRDATA[17]|PRDATA[18]|PRDATA[19]|PRDATA[21]|PRDATA[23]|PRDATA[27]|PRDATA[28]|PRDATA[29]|PRDATA[31]|PRDATA[9]|PSLVERR|VGND
+ sky130_fd_pr__nfet_01v8 L=0.15 W=1.3 AS=0.26975 AD=0.1755 PS=2.78 PD=1.84
M$1237
+ LO|PRDATA[10]|PRDATA[12]|PRDATA[13]|PRDATA[15]|PRDATA[16]|PRDATA[17]|PRDATA[18]|PRDATA[19]|PRDATA[21]|PRDATA[23]|PRDATA[27]|PRDATA[28]|PRDATA[29]|PRDATA[31]|PRDATA[9]|PSLVERR|VGND
+ B|Y PRDATA[22]|Y
+ LO|PRDATA[10]|PRDATA[12]|PRDATA[13]|PRDATA[15]|PRDATA[16]|PRDATA[17]|PRDATA[18]|PRDATA[19]|PRDATA[21]|PRDATA[23]|PRDATA[27]|PRDATA[28]|PRDATA[29]|PRDATA[31]|PRDATA[9]|PSLVERR|VGND
+ sky130_fd_pr__nfet_01v8 L=0.15 W=1.3 AS=0.1755 AD=0.25675 PS=1.84 PD=2.74
M$1239
+ LO|PRDATA[10]|PRDATA[12]|PRDATA[13]|PRDATA[15]|PRDATA[16]|PRDATA[17]|PRDATA[18]|PRDATA[19]|PRDATA[21]|PRDATA[23]|PRDATA[27]|PRDATA[28]|PRDATA[29]|PRDATA[31]|PRDATA[9]|PSLVERR|VGND
+ A|X PRDATA[14]|Y
+ LO|PRDATA[10]|PRDATA[12]|PRDATA[13]|PRDATA[15]|PRDATA[16]|PRDATA[17]|PRDATA[18]|PRDATA[19]|PRDATA[21]|PRDATA[23]|PRDATA[27]|PRDATA[28]|PRDATA[29]|PRDATA[31]|PRDATA[9]|PSLVERR|VGND
+ sky130_fd_pr__nfet_01v8 L=0.15 W=1.3 AS=0.26975 AD=0.1755 PS=2.78 PD=1.84
M$1241
+ LO|PRDATA[10]|PRDATA[12]|PRDATA[13]|PRDATA[15]|PRDATA[16]|PRDATA[17]|PRDATA[18]|PRDATA[19]|PRDATA[21]|PRDATA[23]|PRDATA[27]|PRDATA[28]|PRDATA[29]|PRDATA[31]|PRDATA[9]|PSLVERR|VGND
+ B|Y PRDATA[14]|Y
+ LO|PRDATA[10]|PRDATA[12]|PRDATA[13]|PRDATA[15]|PRDATA[16]|PRDATA[17]|PRDATA[18]|PRDATA[19]|PRDATA[21]|PRDATA[23]|PRDATA[27]|PRDATA[28]|PRDATA[29]|PRDATA[31]|PRDATA[9]|PSLVERR|VGND
+ sky130_fd_pr__nfet_01v8 L=0.15 W=1.3 AS=0.1755 AD=0.25675 PS=1.84 PD=2.74
M$1243
+ LO|PRDATA[10]|PRDATA[12]|PRDATA[13]|PRDATA[15]|PRDATA[16]|PRDATA[17]|PRDATA[18]|PRDATA[19]|PRDATA[21]|PRDATA[23]|PRDATA[27]|PRDATA[28]|PRDATA[29]|PRDATA[31]|PRDATA[9]|PSLVERR|VGND
+ A|X \$699
+ LO|PRDATA[10]|PRDATA[12]|PRDATA[13]|PRDATA[15]|PRDATA[16]|PRDATA[17]|PRDATA[18]|PRDATA[19]|PRDATA[21]|PRDATA[23]|PRDATA[27]|PRDATA[28]|PRDATA[29]|PRDATA[31]|PRDATA[9]|PSLVERR|VGND
+ sky130_fd_pr__nfet_01v8 L=0.15 W=1.68 AS=0.2877 AD=0.2352 PS=3.47 PD=2.8
M$1247
+ LO|PRDATA[10]|PRDATA[12]|PRDATA[13]|PRDATA[15]|PRDATA[16]|PRDATA[17]|PRDATA[18]|PRDATA[19]|PRDATA[21]|PRDATA[23]|PRDATA[27]|PRDATA[28]|PRDATA[29]|PRDATA[31]|PRDATA[9]|PSLVERR|VGND
+ \$699 CLK|X
+ LO|PRDATA[10]|PRDATA[12]|PRDATA[13]|PRDATA[15]|PRDATA[16]|PRDATA[17]|PRDATA[18]|PRDATA[19]|PRDATA[21]|PRDATA[23]|PRDATA[27]|PRDATA[28]|PRDATA[29]|PRDATA[31]|PRDATA[9]|PSLVERR|VGND
+ sky130_fd_pr__nfet_01v8 L=0.15 W=6.72 AS=0.93975 AD=0.99225 PS=11.195
+ PD=11.865
M$1263 \$701 A|X
+ LO|PRDATA[10]|PRDATA[12]|PRDATA[13]|PRDATA[15]|PRDATA[16]|PRDATA[17]|PRDATA[18]|PRDATA[19]|PRDATA[21]|PRDATA[23]|PRDATA[27]|PRDATA[28]|PRDATA[29]|PRDATA[31]|PRDATA[9]|PSLVERR|VGND
+ LO|PRDATA[10]|PRDATA[12]|PRDATA[13]|PRDATA[15]|PRDATA[16]|PRDATA[17]|PRDATA[18]|PRDATA[19]|PRDATA[21]|PRDATA[23]|PRDATA[27]|PRDATA[28]|PRDATA[29]|PRDATA[31]|PRDATA[9]|PSLVERR|VGND
+ sky130_fd_pr__nfet_01v8 L=0.15 W=0.65 AS=0.169 AD=0.08775 PS=1.82 PD=0.92
M$1264
+ LO|PRDATA[10]|PRDATA[12]|PRDATA[13]|PRDATA[15]|PRDATA[16]|PRDATA[17]|PRDATA[18]|PRDATA[19]|PRDATA[21]|PRDATA[23]|PRDATA[27]|PRDATA[28]|PRDATA[29]|PRDATA[31]|PRDATA[9]|PSLVERR|VGND
+ \$701 D|X
+ LO|PRDATA[10]|PRDATA[12]|PRDATA[13]|PRDATA[15]|PRDATA[16]|PRDATA[17]|PRDATA[18]|PRDATA[19]|PRDATA[21]|PRDATA[23]|PRDATA[27]|PRDATA[28]|PRDATA[29]|PRDATA[31]|PRDATA[9]|PSLVERR|VGND
+ sky130_fd_pr__nfet_01v8 L=0.15 W=2.6 AS=0.351 AD=0.43225 PS=3.68 PD=4.58
M$1268
+ LO|PRDATA[10]|PRDATA[12]|PRDATA[13]|PRDATA[15]|PRDATA[16]|PRDATA[17]|PRDATA[18]|PRDATA[19]|PRDATA[21]|PRDATA[23]|PRDATA[27]|PRDATA[28]|PRDATA[29]|PRDATA[31]|PRDATA[9]|PSLVERR|VGND
+ B|B1|B_N|Y \$714
+ LO|PRDATA[10]|PRDATA[12]|PRDATA[13]|PRDATA[15]|PRDATA[16]|PRDATA[17]|PRDATA[18]|PRDATA[19]|PRDATA[21]|PRDATA[23]|PRDATA[27]|PRDATA[28]|PRDATA[29]|PRDATA[31]|PRDATA[9]|PSLVERR|VGND
+ sky130_fd_pr__nfet_01v8 L=0.15 W=0.65 AS=0.169 AD=0.08775 PS=1.82 PD=0.92
M$1269 \$714 A|A0|Q|gpio_oe[4] A1|Y
+ LO|PRDATA[10]|PRDATA[12]|PRDATA[13]|PRDATA[15]|PRDATA[16]|PRDATA[17]|PRDATA[18]|PRDATA[19]|PRDATA[21]|PRDATA[23]|PRDATA[27]|PRDATA[28]|PRDATA[29]|PRDATA[31]|PRDATA[9]|PSLVERR|VGND
+ sky130_fd_pr__nfet_01v8 L=0.15 W=0.65 AS=0.08775 AD=0.169 PS=0.92 PD=1.82
M$1270
+ LO|PRDATA[10]|PRDATA[12]|PRDATA[13]|PRDATA[15]|PRDATA[16]|PRDATA[17]|PRDATA[18]|PRDATA[19]|PRDATA[21]|PRDATA[23]|PRDATA[27]|PRDATA[28]|PRDATA[29]|PRDATA[31]|PRDATA[9]|PSLVERR|VGND
+ A2|Y \$713
+ LO|PRDATA[10]|PRDATA[12]|PRDATA[13]|PRDATA[15]|PRDATA[16]|PRDATA[17]|PRDATA[18]|PRDATA[19]|PRDATA[21]|PRDATA[23]|PRDATA[27]|PRDATA[28]|PRDATA[29]|PRDATA[31]|PRDATA[9]|PSLVERR|VGND
+ sky130_fd_pr__nfet_01v8 L=0.15 W=0.65 AS=0.18525 AD=0.089375 PS=1.87 PD=0.925
M$1271 \$713 A1|Y PRDATA[4]|Y
+ LO|PRDATA[10]|PRDATA[12]|PRDATA[13]|PRDATA[15]|PRDATA[16]|PRDATA[17]|PRDATA[18]|PRDATA[19]|PRDATA[21]|PRDATA[23]|PRDATA[27]|PRDATA[28]|PRDATA[29]|PRDATA[31]|PRDATA[9]|PSLVERR|VGND
+ sky130_fd_pr__nfet_01v8 L=0.15 W=0.65 AS=0.089375 AD=0.091 PS=0.925 PD=0.93
M$1272 PRDATA[4]|Y A1|Y \$712
+ LO|PRDATA[10]|PRDATA[12]|PRDATA[13]|PRDATA[15]|PRDATA[16]|PRDATA[17]|PRDATA[18]|PRDATA[19]|PRDATA[21]|PRDATA[23]|PRDATA[27]|PRDATA[28]|PRDATA[29]|PRDATA[31]|PRDATA[9]|PSLVERR|VGND
+ sky130_fd_pr__nfet_01v8 L=0.15 W=0.65 AS=0.091 AD=0.06825 PS=0.93 PD=0.86
M$1273 \$712 A2|Y
+ LO|PRDATA[10]|PRDATA[12]|PRDATA[13]|PRDATA[15]|PRDATA[16]|PRDATA[17]|PRDATA[18]|PRDATA[19]|PRDATA[21]|PRDATA[23]|PRDATA[27]|PRDATA[28]|PRDATA[29]|PRDATA[31]|PRDATA[9]|PSLVERR|VGND
+ LO|PRDATA[10]|PRDATA[12]|PRDATA[13]|PRDATA[15]|PRDATA[16]|PRDATA[17]|PRDATA[18]|PRDATA[19]|PRDATA[21]|PRDATA[23]|PRDATA[27]|PRDATA[28]|PRDATA[29]|PRDATA[31]|PRDATA[9]|PSLVERR|VGND
+ sky130_fd_pr__nfet_01v8 L=0.15 W=0.65 AS=0.06825 AD=0.10725 PS=0.86 PD=0.98
M$1274
+ LO|PRDATA[10]|PRDATA[12]|PRDATA[13]|PRDATA[15]|PRDATA[16]|PRDATA[17]|PRDATA[18]|PRDATA[19]|PRDATA[21]|PRDATA[23]|PRDATA[27]|PRDATA[28]|PRDATA[29]|PRDATA[31]|PRDATA[9]|PSLVERR|VGND
+ A|B1|X PRDATA[4]|Y
+ LO|PRDATA[10]|PRDATA[12]|PRDATA[13]|PRDATA[15]|PRDATA[16]|PRDATA[17]|PRDATA[18]|PRDATA[19]|PRDATA[21]|PRDATA[23]|PRDATA[27]|PRDATA[28]|PRDATA[29]|PRDATA[31]|PRDATA[9]|PSLVERR|VGND
+ sky130_fd_pr__nfet_01v8 L=0.15 W=1.3 AS=0.195 AD=0.34775 PS=1.9 PD=3.02
M$1276
+ LO|PRDATA[10]|PRDATA[12]|PRDATA[13]|PRDATA[15]|PRDATA[16]|PRDATA[17]|PRDATA[18]|PRDATA[19]|PRDATA[21]|PRDATA[23]|PRDATA[27]|PRDATA[28]|PRDATA[29]|PRDATA[31]|PRDATA[9]|PSLVERR|VGND
+ A|X PRDATA[11]|Y
+ LO|PRDATA[10]|PRDATA[12]|PRDATA[13]|PRDATA[15]|PRDATA[16]|PRDATA[17]|PRDATA[18]|PRDATA[19]|PRDATA[21]|PRDATA[23]|PRDATA[27]|PRDATA[28]|PRDATA[29]|PRDATA[31]|PRDATA[9]|PSLVERR|VGND
+ sky130_fd_pr__nfet_01v8 L=0.15 W=1.3 AS=0.26975 AD=0.1755 PS=2.78 PD=1.84
M$1278
+ LO|PRDATA[10]|PRDATA[12]|PRDATA[13]|PRDATA[15]|PRDATA[16]|PRDATA[17]|PRDATA[18]|PRDATA[19]|PRDATA[21]|PRDATA[23]|PRDATA[27]|PRDATA[28]|PRDATA[29]|PRDATA[31]|PRDATA[9]|PSLVERR|VGND
+ B|Y PRDATA[11]|Y
+ LO|PRDATA[10]|PRDATA[12]|PRDATA[13]|PRDATA[15]|PRDATA[16]|PRDATA[17]|PRDATA[18]|PRDATA[19]|PRDATA[21]|PRDATA[23]|PRDATA[27]|PRDATA[28]|PRDATA[29]|PRDATA[31]|PRDATA[9]|PSLVERR|VGND
+ sky130_fd_pr__nfet_01v8 L=0.15 W=1.3 AS=0.1755 AD=0.25675 PS=1.84 PD=2.74
M$1280
+ LO|PRDATA[10]|PRDATA[12]|PRDATA[13]|PRDATA[15]|PRDATA[16]|PRDATA[17]|PRDATA[18]|PRDATA[19]|PRDATA[21]|PRDATA[23]|PRDATA[27]|PRDATA[28]|PRDATA[29]|PRDATA[31]|PRDATA[9]|PSLVERR|VGND
+ A|X \$716
+ LO|PRDATA[10]|PRDATA[12]|PRDATA[13]|PRDATA[15]|PRDATA[16]|PRDATA[17]|PRDATA[18]|PRDATA[19]|PRDATA[21]|PRDATA[23]|PRDATA[27]|PRDATA[28]|PRDATA[29]|PRDATA[31]|PRDATA[9]|PSLVERR|VGND
+ sky130_fd_pr__nfet_01v8 L=0.15 W=1.3 AS=0.25675 AD=0.1755 PS=2.74 PD=1.84
M$1282
+ LO|PRDATA[10]|PRDATA[12]|PRDATA[13]|PRDATA[15]|PRDATA[16]|PRDATA[17]|PRDATA[18]|PRDATA[19]|PRDATA[21]|PRDATA[23]|PRDATA[27]|PRDATA[28]|PRDATA[29]|PRDATA[31]|PRDATA[9]|PSLVERR|VGND
+ \$716 D|X
+ LO|PRDATA[10]|PRDATA[12]|PRDATA[13]|PRDATA[15]|PRDATA[16]|PRDATA[17]|PRDATA[18]|PRDATA[19]|PRDATA[21]|PRDATA[23]|PRDATA[27]|PRDATA[28]|PRDATA[29]|PRDATA[31]|PRDATA[9]|PSLVERR|VGND
+ sky130_fd_pr__nfet_01v8 L=0.15 W=3.9 AS=0.5265 AD=0.60775 PS=5.52 PD=6.42
M$1288 \$718 A|X
+ LO|PRDATA[10]|PRDATA[12]|PRDATA[13]|PRDATA[15]|PRDATA[16]|PRDATA[17]|PRDATA[18]|PRDATA[19]|PRDATA[21]|PRDATA[23]|PRDATA[27]|PRDATA[28]|PRDATA[29]|PRDATA[31]|PRDATA[9]|PSLVERR|VGND
+ LO|PRDATA[10]|PRDATA[12]|PRDATA[13]|PRDATA[15]|PRDATA[16]|PRDATA[17]|PRDATA[18]|PRDATA[19]|PRDATA[21]|PRDATA[23]|PRDATA[27]|PRDATA[28]|PRDATA[29]|PRDATA[31]|PRDATA[9]|PSLVERR|VGND
+ sky130_fd_pr__nfet_01v8 L=0.15 W=0.65 AS=0.169 AD=0.08775 PS=1.82 PD=0.92
M$1289
+ LO|PRDATA[10]|PRDATA[12]|PRDATA[13]|PRDATA[15]|PRDATA[16]|PRDATA[17]|PRDATA[18]|PRDATA[19]|PRDATA[21]|PRDATA[23]|PRDATA[27]|PRDATA[28]|PRDATA[29]|PRDATA[31]|PRDATA[9]|PSLVERR|VGND
+ \$718 D|X
+ LO|PRDATA[10]|PRDATA[12]|PRDATA[13]|PRDATA[15]|PRDATA[16]|PRDATA[17]|PRDATA[18]|PRDATA[19]|PRDATA[21]|PRDATA[23]|PRDATA[27]|PRDATA[28]|PRDATA[29]|PRDATA[31]|PRDATA[9]|PSLVERR|VGND
+ sky130_fd_pr__nfet_01v8 L=0.15 W=2.6 AS=0.351 AD=0.43225 PS=3.68 PD=4.58
M$1293 \$720 CLK|X
+ LO|PRDATA[10]|PRDATA[12]|PRDATA[13]|PRDATA[15]|PRDATA[16]|PRDATA[17]|PRDATA[18]|PRDATA[19]|PRDATA[21]|PRDATA[23]|PRDATA[27]|PRDATA[28]|PRDATA[29]|PRDATA[31]|PRDATA[9]|PSLVERR|VGND
+ LO|PRDATA[10]|PRDATA[12]|PRDATA[13]|PRDATA[15]|PRDATA[16]|PRDATA[17]|PRDATA[18]|PRDATA[19]|PRDATA[21]|PRDATA[23]|PRDATA[27]|PRDATA[28]|PRDATA[29]|PRDATA[31]|PRDATA[9]|PSLVERR|VGND
+ sky130_fd_pr__nfet_01v8 L=0.15 W=0.42 AS=0.1092 AD=0.0567 PS=1.36 PD=0.69
M$1294
+ LO|PRDATA[10]|PRDATA[12]|PRDATA[13]|PRDATA[15]|PRDATA[16]|PRDATA[17]|PRDATA[18]|PRDATA[19]|PRDATA[21]|PRDATA[23]|PRDATA[27]|PRDATA[28]|PRDATA[29]|PRDATA[31]|PRDATA[9]|PSLVERR|VGND
+ \$720 \$721
+ LO|PRDATA[10]|PRDATA[12]|PRDATA[13]|PRDATA[15]|PRDATA[16]|PRDATA[17]|PRDATA[18]|PRDATA[19]|PRDATA[21]|PRDATA[23]|PRDATA[27]|PRDATA[28]|PRDATA[29]|PRDATA[31]|PRDATA[9]|PSLVERR|VGND
+ sky130_fd_pr__nfet_01v8 L=0.15 W=0.42 AS=0.0567 AD=0.1092 PS=0.69 PD=1.36
M$1295 \$722 \$720 \$723
+ LO|PRDATA[10]|PRDATA[12]|PRDATA[13]|PRDATA[15]|PRDATA[16]|PRDATA[17]|PRDATA[18]|PRDATA[19]|PRDATA[21]|PRDATA[23]|PRDATA[27]|PRDATA[28]|PRDATA[29]|PRDATA[31]|PRDATA[9]|PSLVERR|VGND
+ sky130_fd_pr__nfet_01v8 L=0.15 W=0.36 AS=0.066 AD=0.0594 PS=0.745 PD=0.69
M$1296 \$723 \$721 \$755
+ LO|PRDATA[10]|PRDATA[12]|PRDATA[13]|PRDATA[15]|PRDATA[16]|PRDATA[17]|PRDATA[18]|PRDATA[19]|PRDATA[21]|PRDATA[23]|PRDATA[27]|PRDATA[28]|PRDATA[29]|PRDATA[31]|PRDATA[9]|PSLVERR|VGND
+ sky130_fd_pr__nfet_01v8 L=0.15 W=0.36 AS=0.0594 AD=0.1401 PS=0.69 PD=1.1
M$1297 \$779 \$721 \$724
+ LO|PRDATA[10]|PRDATA[12]|PRDATA[13]|PRDATA[15]|PRDATA[16]|PRDATA[17]|PRDATA[18]|PRDATA[19]|PRDATA[21]|PRDATA[23]|PRDATA[27]|PRDATA[28]|PRDATA[29]|PRDATA[31]|PRDATA[9]|PSLVERR|VGND
+ sky130_fd_pr__nfet_01v8 L=0.15 W=0.36 AS=0.0999 AD=0.0711 PS=0.985 PD=0.755
M$1298 \$724 \$720 \$760
+ LO|PRDATA[10]|PRDATA[12]|PRDATA[13]|PRDATA[15]|PRDATA[16]|PRDATA[17]|PRDATA[18]|PRDATA[19]|PRDATA[21]|PRDATA[23]|PRDATA[27]|PRDATA[28]|PRDATA[29]|PRDATA[31]|PRDATA[9]|PSLVERR|VGND
+ sky130_fd_pr__nfet_01v8 L=0.15 W=0.36 AS=0.0711 AD=0.0669 PS=0.755 PD=0.75
M$1299
+ LO|PRDATA[10]|PRDATA[12]|PRDATA[13]|PRDATA[15]|PRDATA[16]|PRDATA[17]|PRDATA[18]|PRDATA[19]|PRDATA[21]|PRDATA[23]|PRDATA[27]|PRDATA[28]|PRDATA[29]|PRDATA[31]|PRDATA[9]|PSLVERR|VGND
+ D|X \$722
+ LO|PRDATA[10]|PRDATA[12]|PRDATA[13]|PRDATA[15]|PRDATA[16]|PRDATA[17]|PRDATA[18]|PRDATA[19]|PRDATA[21]|PRDATA[23]|PRDATA[27]|PRDATA[28]|PRDATA[29]|PRDATA[31]|PRDATA[9]|PSLVERR|VGND
+ sky130_fd_pr__nfet_01v8 L=0.15 W=0.42 AS=0.2205 AD=0.066 PS=1.89 PD=0.745
M$1300 \$755 \$779 \$756
+ LO|PRDATA[10]|PRDATA[12]|PRDATA[13]|PRDATA[15]|PRDATA[16]|PRDATA[17]|PRDATA[18]|PRDATA[19]|PRDATA[21]|PRDATA[23]|PRDATA[27]|PRDATA[28]|PRDATA[29]|PRDATA[31]|PRDATA[9]|PSLVERR|VGND
+ sky130_fd_pr__nfet_01v8 L=0.15 W=0.42 AS=0.1401 AD=0.0441 PS=1.1 PD=0.63
M$1301 \$756 PRESETn|RESET_B
+ LO|PRDATA[10]|PRDATA[12]|PRDATA[13]|PRDATA[15]|PRDATA[16]|PRDATA[17]|PRDATA[18]|PRDATA[19]|PRDATA[21]|PRDATA[23]|PRDATA[27]|PRDATA[28]|PRDATA[29]|PRDATA[31]|PRDATA[9]|PSLVERR|VGND
+ LO|PRDATA[10]|PRDATA[12]|PRDATA[13]|PRDATA[15]|PRDATA[16]|PRDATA[17]|PRDATA[18]|PRDATA[19]|PRDATA[21]|PRDATA[23]|PRDATA[27]|PRDATA[28]|PRDATA[29]|PRDATA[31]|PRDATA[9]|PSLVERR|VGND
+ sky130_fd_pr__nfet_01v8 L=0.15 W=0.42 AS=0.0441 AD=0.1346 PS=0.63 PD=1.15
M$1302 \$760 \$725
+ LO|PRDATA[10]|PRDATA[12]|PRDATA[13]|PRDATA[15]|PRDATA[16]|PRDATA[17]|PRDATA[18]|PRDATA[19]|PRDATA[21]|PRDATA[23]|PRDATA[27]|PRDATA[28]|PRDATA[29]|PRDATA[31]|PRDATA[9]|PSLVERR|VGND
+ LO|PRDATA[10]|PRDATA[12]|PRDATA[13]|PRDATA[15]|PRDATA[16]|PRDATA[17]|PRDATA[18]|PRDATA[19]|PRDATA[21]|PRDATA[23]|PRDATA[27]|PRDATA[28]|PRDATA[29]|PRDATA[31]|PRDATA[9]|PSLVERR|VGND
+ sky130_fd_pr__nfet_01v8 L=0.15 W=0.42 AS=0.0669 AD=0.12495 PS=0.75 PD=1.015
M$1303
+ LO|PRDATA[10]|PRDATA[12]|PRDATA[13]|PRDATA[15]|PRDATA[16]|PRDATA[17]|PRDATA[18]|PRDATA[19]|PRDATA[21]|PRDATA[23]|PRDATA[27]|PRDATA[28]|PRDATA[29]|PRDATA[31]|PRDATA[9]|PSLVERR|VGND
+ PRESETn|RESET_B \$763
+ LO|PRDATA[10]|PRDATA[12]|PRDATA[13]|PRDATA[15]|PRDATA[16]|PRDATA[17]|PRDATA[18]|PRDATA[19]|PRDATA[21]|PRDATA[23]|PRDATA[27]|PRDATA[28]|PRDATA[29]|PRDATA[31]|PRDATA[9]|PSLVERR|VGND
+ sky130_fd_pr__nfet_01v8 L=0.15 W=0.42 AS=0.12495 AD=0.06405 PS=1.015 PD=0.725
M$1304 \$763 \$724 \$725
+ LO|PRDATA[10]|PRDATA[12]|PRDATA[13]|PRDATA[15]|PRDATA[16]|PRDATA[17]|PRDATA[18]|PRDATA[19]|PRDATA[21]|PRDATA[23]|PRDATA[27]|PRDATA[28]|PRDATA[29]|PRDATA[31]|PRDATA[9]|PSLVERR|VGND
+ sky130_fd_pr__nfet_01v8 L=0.15 W=0.42 AS=0.06405 AD=0.1092 PS=0.725 PD=1.36
M$1305
+ LO|PRDATA[10]|PRDATA[12]|PRDATA[13]|PRDATA[15]|PRDATA[16]|PRDATA[17]|PRDATA[18]|PRDATA[19]|PRDATA[21]|PRDATA[23]|PRDATA[27]|PRDATA[28]|PRDATA[29]|PRDATA[31]|PRDATA[9]|PSLVERR|VGND
+ \$723 \$779
+ LO|PRDATA[10]|PRDATA[12]|PRDATA[13]|PRDATA[15]|PRDATA[16]|PRDATA[17]|PRDATA[18]|PRDATA[19]|PRDATA[21]|PRDATA[23]|PRDATA[27]|PRDATA[28]|PRDATA[29]|PRDATA[31]|PRDATA[9]|PSLVERR|VGND
+ sky130_fd_pr__nfet_01v8 L=0.15 W=0.64 AS=0.1346 AD=0.0999 PS=1.15 PD=0.985
M$1306
+ LO|PRDATA[10]|PRDATA[12]|PRDATA[13]|PRDATA[15]|PRDATA[16]|PRDATA[17]|PRDATA[18]|PRDATA[19]|PRDATA[21]|PRDATA[23]|PRDATA[27]|PRDATA[28]|PRDATA[29]|PRDATA[31]|PRDATA[9]|PSLVERR|VGND
+ \$725 A0|C1|Q|gpio_out[5]
+ LO|PRDATA[10]|PRDATA[12]|PRDATA[13]|PRDATA[15]|PRDATA[16]|PRDATA[17]|PRDATA[18]|PRDATA[19]|PRDATA[21]|PRDATA[23]|PRDATA[27]|PRDATA[28]|PRDATA[29]|PRDATA[31]|PRDATA[9]|PSLVERR|VGND
+ sky130_fd_pr__nfet_01v8 L=0.15 W=0.65 AS=0.2087 AD=0.169 PS=2.02 PD=1.82
M$1307 \$726 CLK|X
+ LO|PRDATA[10]|PRDATA[12]|PRDATA[13]|PRDATA[15]|PRDATA[16]|PRDATA[17]|PRDATA[18]|PRDATA[19]|PRDATA[21]|PRDATA[23]|PRDATA[27]|PRDATA[28]|PRDATA[29]|PRDATA[31]|PRDATA[9]|PSLVERR|VGND
+ LO|PRDATA[10]|PRDATA[12]|PRDATA[13]|PRDATA[15]|PRDATA[16]|PRDATA[17]|PRDATA[18]|PRDATA[19]|PRDATA[21]|PRDATA[23]|PRDATA[27]|PRDATA[28]|PRDATA[29]|PRDATA[31]|PRDATA[9]|PSLVERR|VGND
+ sky130_fd_pr__nfet_01v8 L=0.15 W=0.42 AS=0.1092 AD=0.0567 PS=1.36 PD=0.69
M$1308
+ LO|PRDATA[10]|PRDATA[12]|PRDATA[13]|PRDATA[15]|PRDATA[16]|PRDATA[17]|PRDATA[18]|PRDATA[19]|PRDATA[21]|PRDATA[23]|PRDATA[27]|PRDATA[28]|PRDATA[29]|PRDATA[31]|PRDATA[9]|PSLVERR|VGND
+ \$726 \$727
+ LO|PRDATA[10]|PRDATA[12]|PRDATA[13]|PRDATA[15]|PRDATA[16]|PRDATA[17]|PRDATA[18]|PRDATA[19]|PRDATA[21]|PRDATA[23]|PRDATA[27]|PRDATA[28]|PRDATA[29]|PRDATA[31]|PRDATA[9]|PSLVERR|VGND
+ sky130_fd_pr__nfet_01v8 L=0.15 W=0.42 AS=0.0567 AD=0.1092 PS=0.69 PD=1.36
M$1309 \$728 \$726 \$729
+ LO|PRDATA[10]|PRDATA[12]|PRDATA[13]|PRDATA[15]|PRDATA[16]|PRDATA[17]|PRDATA[18]|PRDATA[19]|PRDATA[21]|PRDATA[23]|PRDATA[27]|PRDATA[28]|PRDATA[29]|PRDATA[31]|PRDATA[9]|PSLVERR|VGND
+ sky130_fd_pr__nfet_01v8 L=0.15 W=0.36 AS=0.066 AD=0.0594 PS=0.745 PD=0.69
M$1310 \$729 \$727 \$771
+ LO|PRDATA[10]|PRDATA[12]|PRDATA[13]|PRDATA[15]|PRDATA[16]|PRDATA[17]|PRDATA[18]|PRDATA[19]|PRDATA[21]|PRDATA[23]|PRDATA[27]|PRDATA[28]|PRDATA[29]|PRDATA[31]|PRDATA[9]|PSLVERR|VGND
+ sky130_fd_pr__nfet_01v8 L=0.15 W=0.36 AS=0.0594 AD=0.1401 PS=0.69 PD=1.1
M$1311 \$780 \$727 \$730
+ LO|PRDATA[10]|PRDATA[12]|PRDATA[13]|PRDATA[15]|PRDATA[16]|PRDATA[17]|PRDATA[18]|PRDATA[19]|PRDATA[21]|PRDATA[23]|PRDATA[27]|PRDATA[28]|PRDATA[29]|PRDATA[31]|PRDATA[9]|PSLVERR|VGND
+ sky130_fd_pr__nfet_01v8 L=0.15 W=0.36 AS=0.0999 AD=0.0711 PS=0.985 PD=0.755
M$1312 \$730 \$726 \$774
+ LO|PRDATA[10]|PRDATA[12]|PRDATA[13]|PRDATA[15]|PRDATA[16]|PRDATA[17]|PRDATA[18]|PRDATA[19]|PRDATA[21]|PRDATA[23]|PRDATA[27]|PRDATA[28]|PRDATA[29]|PRDATA[31]|PRDATA[9]|PSLVERR|VGND
+ sky130_fd_pr__nfet_01v8 L=0.15 W=0.36 AS=0.0711 AD=0.0669 PS=0.755 PD=0.75
M$1313
+ LO|PRDATA[10]|PRDATA[12]|PRDATA[13]|PRDATA[15]|PRDATA[16]|PRDATA[17]|PRDATA[18]|PRDATA[19]|PRDATA[21]|PRDATA[23]|PRDATA[27]|PRDATA[28]|PRDATA[29]|PRDATA[31]|PRDATA[9]|PSLVERR|VGND
+ D|X \$728
+ LO|PRDATA[10]|PRDATA[12]|PRDATA[13]|PRDATA[15]|PRDATA[16]|PRDATA[17]|PRDATA[18]|PRDATA[19]|PRDATA[21]|PRDATA[23]|PRDATA[27]|PRDATA[28]|PRDATA[29]|PRDATA[31]|PRDATA[9]|PSLVERR|VGND
+ sky130_fd_pr__nfet_01v8 L=0.15 W=0.42 AS=0.2205 AD=0.066 PS=1.89 PD=0.745
M$1314 \$771 \$780 \$772
+ LO|PRDATA[10]|PRDATA[12]|PRDATA[13]|PRDATA[15]|PRDATA[16]|PRDATA[17]|PRDATA[18]|PRDATA[19]|PRDATA[21]|PRDATA[23]|PRDATA[27]|PRDATA[28]|PRDATA[29]|PRDATA[31]|PRDATA[9]|PSLVERR|VGND
+ sky130_fd_pr__nfet_01v8 L=0.15 W=0.42 AS=0.1401 AD=0.0441 PS=1.1 PD=0.63
M$1315 \$772 PRESETn|RESET_B
+ LO|PRDATA[10]|PRDATA[12]|PRDATA[13]|PRDATA[15]|PRDATA[16]|PRDATA[17]|PRDATA[18]|PRDATA[19]|PRDATA[21]|PRDATA[23]|PRDATA[27]|PRDATA[28]|PRDATA[29]|PRDATA[31]|PRDATA[9]|PSLVERR|VGND
+ LO|PRDATA[10]|PRDATA[12]|PRDATA[13]|PRDATA[15]|PRDATA[16]|PRDATA[17]|PRDATA[18]|PRDATA[19]|PRDATA[21]|PRDATA[23]|PRDATA[27]|PRDATA[28]|PRDATA[29]|PRDATA[31]|PRDATA[9]|PSLVERR|VGND
+ sky130_fd_pr__nfet_01v8 L=0.15 W=0.42 AS=0.0441 AD=0.1346 PS=0.63 PD=1.15
M$1316 \$774 \$731
+ LO|PRDATA[10]|PRDATA[12]|PRDATA[13]|PRDATA[15]|PRDATA[16]|PRDATA[17]|PRDATA[18]|PRDATA[19]|PRDATA[21]|PRDATA[23]|PRDATA[27]|PRDATA[28]|PRDATA[29]|PRDATA[31]|PRDATA[9]|PSLVERR|VGND
+ LO|PRDATA[10]|PRDATA[12]|PRDATA[13]|PRDATA[15]|PRDATA[16]|PRDATA[17]|PRDATA[18]|PRDATA[19]|PRDATA[21]|PRDATA[23]|PRDATA[27]|PRDATA[28]|PRDATA[29]|PRDATA[31]|PRDATA[9]|PSLVERR|VGND
+ sky130_fd_pr__nfet_01v8 L=0.15 W=0.42 AS=0.0669 AD=0.12495 PS=0.75 PD=1.015
M$1317
+ LO|PRDATA[10]|PRDATA[12]|PRDATA[13]|PRDATA[15]|PRDATA[16]|PRDATA[17]|PRDATA[18]|PRDATA[19]|PRDATA[21]|PRDATA[23]|PRDATA[27]|PRDATA[28]|PRDATA[29]|PRDATA[31]|PRDATA[9]|PSLVERR|VGND
+ PRESETn|RESET_B \$777
+ LO|PRDATA[10]|PRDATA[12]|PRDATA[13]|PRDATA[15]|PRDATA[16]|PRDATA[17]|PRDATA[18]|PRDATA[19]|PRDATA[21]|PRDATA[23]|PRDATA[27]|PRDATA[28]|PRDATA[29]|PRDATA[31]|PRDATA[9]|PSLVERR|VGND
+ sky130_fd_pr__nfet_01v8 L=0.15 W=0.42 AS=0.12495 AD=0.06405 PS=1.015 PD=0.725
M$1318 \$777 \$730 \$731
+ LO|PRDATA[10]|PRDATA[12]|PRDATA[13]|PRDATA[15]|PRDATA[16]|PRDATA[17]|PRDATA[18]|PRDATA[19]|PRDATA[21]|PRDATA[23]|PRDATA[27]|PRDATA[28]|PRDATA[29]|PRDATA[31]|PRDATA[9]|PSLVERR|VGND
+ sky130_fd_pr__nfet_01v8 L=0.15 W=0.42 AS=0.06405 AD=0.1092 PS=0.725 PD=1.36
M$1319
+ LO|PRDATA[10]|PRDATA[12]|PRDATA[13]|PRDATA[15]|PRDATA[16]|PRDATA[17]|PRDATA[18]|PRDATA[19]|PRDATA[21]|PRDATA[23]|PRDATA[27]|PRDATA[28]|PRDATA[29]|PRDATA[31]|PRDATA[9]|PSLVERR|VGND
+ \$729 \$780
+ LO|PRDATA[10]|PRDATA[12]|PRDATA[13]|PRDATA[15]|PRDATA[16]|PRDATA[17]|PRDATA[18]|PRDATA[19]|PRDATA[21]|PRDATA[23]|PRDATA[27]|PRDATA[28]|PRDATA[29]|PRDATA[31]|PRDATA[9]|PSLVERR|VGND
+ sky130_fd_pr__nfet_01v8 L=0.15 W=0.64 AS=0.1346 AD=0.0999 PS=1.15 PD=0.985
M$1320
+ LO|PRDATA[10]|PRDATA[12]|PRDATA[13]|PRDATA[15]|PRDATA[16]|PRDATA[17]|PRDATA[18]|PRDATA[19]|PRDATA[21]|PRDATA[23]|PRDATA[27]|PRDATA[28]|PRDATA[29]|PRDATA[31]|PRDATA[9]|PSLVERR|VGND
+ \$731 A|A0|Q|gpio_oe[4]
+ LO|PRDATA[10]|PRDATA[12]|PRDATA[13]|PRDATA[15]|PRDATA[16]|PRDATA[17]|PRDATA[18]|PRDATA[19]|PRDATA[21]|PRDATA[23]|PRDATA[27]|PRDATA[28]|PRDATA[29]|PRDATA[31]|PRDATA[9]|PSLVERR|VGND
+ sky130_fd_pr__nfet_01v8 L=0.15 W=0.65 AS=0.2087 AD=0.169 PS=2.02 PD=1.82
M$1321 \$787 CLK|X
+ LO|PRDATA[10]|PRDATA[12]|PRDATA[13]|PRDATA[15]|PRDATA[16]|PRDATA[17]|PRDATA[18]|PRDATA[19]|PRDATA[21]|PRDATA[23]|PRDATA[27]|PRDATA[28]|PRDATA[29]|PRDATA[31]|PRDATA[9]|PSLVERR|VGND
+ LO|PRDATA[10]|PRDATA[12]|PRDATA[13]|PRDATA[15]|PRDATA[16]|PRDATA[17]|PRDATA[18]|PRDATA[19]|PRDATA[21]|PRDATA[23]|PRDATA[27]|PRDATA[28]|PRDATA[29]|PRDATA[31]|PRDATA[9]|PSLVERR|VGND
+ sky130_fd_pr__nfet_01v8 L=0.15 W=0.42 AS=0.1092 AD=0.0567 PS=1.36 PD=0.69
M$1322
+ LO|PRDATA[10]|PRDATA[12]|PRDATA[13]|PRDATA[15]|PRDATA[16]|PRDATA[17]|PRDATA[18]|PRDATA[19]|PRDATA[21]|PRDATA[23]|PRDATA[27]|PRDATA[28]|PRDATA[29]|PRDATA[31]|PRDATA[9]|PSLVERR|VGND
+ \$787 \$788
+ LO|PRDATA[10]|PRDATA[12]|PRDATA[13]|PRDATA[15]|PRDATA[16]|PRDATA[17]|PRDATA[18]|PRDATA[19]|PRDATA[21]|PRDATA[23]|PRDATA[27]|PRDATA[28]|PRDATA[29]|PRDATA[31]|PRDATA[9]|PSLVERR|VGND
+ sky130_fd_pr__nfet_01v8 L=0.15 W=0.42 AS=0.0567 AD=0.1092 PS=0.69 PD=1.36
M$1323
+ LO|PRDATA[10]|PRDATA[12]|PRDATA[13]|PRDATA[15]|PRDATA[16]|PRDATA[17]|PRDATA[18]|PRDATA[19]|PRDATA[21]|PRDATA[23]|PRDATA[27]|PRDATA[28]|PRDATA[29]|PRDATA[31]|PRDATA[9]|PSLVERR|VGND
+ D|X \$790
+ LO|PRDATA[10]|PRDATA[12]|PRDATA[13]|PRDATA[15]|PRDATA[16]|PRDATA[17]|PRDATA[18]|PRDATA[19]|PRDATA[21]|PRDATA[23]|PRDATA[27]|PRDATA[28]|PRDATA[29]|PRDATA[31]|PRDATA[9]|PSLVERR|VGND
+ sky130_fd_pr__nfet_01v8 L=0.15 W=0.42 AS=0.2205 AD=0.066 PS=1.89 PD=0.745
M$1324 \$790 \$787 \$791
+ LO|PRDATA[10]|PRDATA[12]|PRDATA[13]|PRDATA[15]|PRDATA[16]|PRDATA[17]|PRDATA[18]|PRDATA[19]|PRDATA[21]|PRDATA[23]|PRDATA[27]|PRDATA[28]|PRDATA[29]|PRDATA[31]|PRDATA[9]|PSLVERR|VGND
+ sky130_fd_pr__nfet_01v8 L=0.15 W=0.36 AS=0.066 AD=0.0594 PS=0.745 PD=0.69
M$1325 \$832 \$788 \$791
+ LO|PRDATA[10]|PRDATA[12]|PRDATA[13]|PRDATA[15]|PRDATA[16]|PRDATA[17]|PRDATA[18]|PRDATA[19]|PRDATA[21]|PRDATA[23]|PRDATA[27]|PRDATA[28]|PRDATA[29]|PRDATA[31]|PRDATA[9]|PSLVERR|VGND
+ sky130_fd_pr__nfet_01v8 L=0.15 W=0.36 AS=0.1401 AD=0.0594 PS=1.1 PD=0.69
M$1326 \$832 \$793 \$833
+ LO|PRDATA[10]|PRDATA[12]|PRDATA[13]|PRDATA[15]|PRDATA[16]|PRDATA[17]|PRDATA[18]|PRDATA[19]|PRDATA[21]|PRDATA[23]|PRDATA[27]|PRDATA[28]|PRDATA[29]|PRDATA[31]|PRDATA[9]|PSLVERR|VGND
+ sky130_fd_pr__nfet_01v8 L=0.15 W=0.42 AS=0.1401 AD=0.0441 PS=1.1 PD=0.63
M$1327
+ LO|PRDATA[10]|PRDATA[12]|PRDATA[13]|PRDATA[15]|PRDATA[16]|PRDATA[17]|PRDATA[18]|PRDATA[19]|PRDATA[21]|PRDATA[23]|PRDATA[27]|PRDATA[28]|PRDATA[29]|PRDATA[31]|PRDATA[9]|PSLVERR|VGND
+ PRESETn|RESET_B \$833
+ LO|PRDATA[10]|PRDATA[12]|PRDATA[13]|PRDATA[15]|PRDATA[16]|PRDATA[17]|PRDATA[18]|PRDATA[19]|PRDATA[21]|PRDATA[23]|PRDATA[27]|PRDATA[28]|PRDATA[29]|PRDATA[31]|PRDATA[9]|PSLVERR|VGND
+ sky130_fd_pr__nfet_01v8 L=0.15 W=0.42 AS=0.1346 AD=0.0441 PS=1.15 PD=0.63
M$1328
+ LO|PRDATA[10]|PRDATA[12]|PRDATA[13]|PRDATA[15]|PRDATA[16]|PRDATA[17]|PRDATA[18]|PRDATA[19]|PRDATA[21]|PRDATA[23]|PRDATA[27]|PRDATA[28]|PRDATA[29]|PRDATA[31]|PRDATA[9]|PSLVERR|VGND
+ \$791 \$793
+ LO|PRDATA[10]|PRDATA[12]|PRDATA[13]|PRDATA[15]|PRDATA[16]|PRDATA[17]|PRDATA[18]|PRDATA[19]|PRDATA[21]|PRDATA[23]|PRDATA[27]|PRDATA[28]|PRDATA[29]|PRDATA[31]|PRDATA[9]|PSLVERR|VGND
+ sky130_fd_pr__nfet_01v8 L=0.15 W=0.64 AS=0.1346 AD=0.0999 PS=1.15 PD=0.985
M$1329 \$793 \$788 \$794
+ LO|PRDATA[10]|PRDATA[12]|PRDATA[13]|PRDATA[15]|PRDATA[16]|PRDATA[17]|PRDATA[18]|PRDATA[19]|PRDATA[21]|PRDATA[23]|PRDATA[27]|PRDATA[28]|PRDATA[29]|PRDATA[31]|PRDATA[9]|PSLVERR|VGND
+ sky130_fd_pr__nfet_01v8 L=0.15 W=0.36 AS=0.0999 AD=0.0711 PS=0.985 PD=0.755
M$1330 \$831 \$787 \$794
+ LO|PRDATA[10]|PRDATA[12]|PRDATA[13]|PRDATA[15]|PRDATA[16]|PRDATA[17]|PRDATA[18]|PRDATA[19]|PRDATA[21]|PRDATA[23]|PRDATA[27]|PRDATA[28]|PRDATA[29]|PRDATA[31]|PRDATA[9]|PSLVERR|VGND
+ sky130_fd_pr__nfet_01v8 L=0.15 W=0.36 AS=0.0669 AD=0.0711 PS=0.75 PD=0.755
M$1331 \$831 \$817
+ LO|PRDATA[10]|PRDATA[12]|PRDATA[13]|PRDATA[15]|PRDATA[16]|PRDATA[17]|PRDATA[18]|PRDATA[19]|PRDATA[21]|PRDATA[23]|PRDATA[27]|PRDATA[28]|PRDATA[29]|PRDATA[31]|PRDATA[9]|PSLVERR|VGND
+ LO|PRDATA[10]|PRDATA[12]|PRDATA[13]|PRDATA[15]|PRDATA[16]|PRDATA[17]|PRDATA[18]|PRDATA[19]|PRDATA[21]|PRDATA[23]|PRDATA[27]|PRDATA[28]|PRDATA[29]|PRDATA[31]|PRDATA[9]|PSLVERR|VGND
+ sky130_fd_pr__nfet_01v8 L=0.15 W=0.42 AS=0.0669 AD=0.12495 PS=0.75 PD=1.015
M$1332
+ LO|PRDATA[10]|PRDATA[12]|PRDATA[13]|PRDATA[15]|PRDATA[16]|PRDATA[17]|PRDATA[18]|PRDATA[19]|PRDATA[21]|PRDATA[23]|PRDATA[27]|PRDATA[28]|PRDATA[29]|PRDATA[31]|PRDATA[9]|PSLVERR|VGND
+ PRESETn|RESET_B \$830
+ LO|PRDATA[10]|PRDATA[12]|PRDATA[13]|PRDATA[15]|PRDATA[16]|PRDATA[17]|PRDATA[18]|PRDATA[19]|PRDATA[21]|PRDATA[23]|PRDATA[27]|PRDATA[28]|PRDATA[29]|PRDATA[31]|PRDATA[9]|PSLVERR|VGND
+ sky130_fd_pr__nfet_01v8 L=0.15 W=0.42 AS=0.12495 AD=0.06405 PS=1.015 PD=0.725
M$1333 \$830 \$794 \$817
+ LO|PRDATA[10]|PRDATA[12]|PRDATA[13]|PRDATA[15]|PRDATA[16]|PRDATA[17]|PRDATA[18]|PRDATA[19]|PRDATA[21]|PRDATA[23]|PRDATA[27]|PRDATA[28]|PRDATA[29]|PRDATA[31]|PRDATA[9]|PSLVERR|VGND
+ sky130_fd_pr__nfet_01v8 L=0.15 W=0.42 AS=0.06405 AD=0.1092 PS=0.725 PD=1.36
M$1334
+ LO|PRDATA[10]|PRDATA[12]|PRDATA[13]|PRDATA[15]|PRDATA[16]|PRDATA[17]|PRDATA[18]|PRDATA[19]|PRDATA[21]|PRDATA[23]|PRDATA[27]|PRDATA[28]|PRDATA[29]|PRDATA[31]|PRDATA[9]|PSLVERR|VGND
+ \$817 A0|B2|Q|gpio_oe[7]
+ LO|PRDATA[10]|PRDATA[12]|PRDATA[13]|PRDATA[15]|PRDATA[16]|PRDATA[17]|PRDATA[18]|PRDATA[19]|PRDATA[21]|PRDATA[23]|PRDATA[27]|PRDATA[28]|PRDATA[29]|PRDATA[31]|PRDATA[9]|PSLVERR|VGND
+ sky130_fd_pr__nfet_01v8 L=0.15 W=0.65 AS=0.2087 AD=0.169 PS=2.02 PD=1.82
M$1335 \$796 CLK|X
+ LO|PRDATA[10]|PRDATA[12]|PRDATA[13]|PRDATA[15]|PRDATA[16]|PRDATA[17]|PRDATA[18]|PRDATA[19]|PRDATA[21]|PRDATA[23]|PRDATA[27]|PRDATA[28]|PRDATA[29]|PRDATA[31]|PRDATA[9]|PSLVERR|VGND
+ LO|PRDATA[10]|PRDATA[12]|PRDATA[13]|PRDATA[15]|PRDATA[16]|PRDATA[17]|PRDATA[18]|PRDATA[19]|PRDATA[21]|PRDATA[23]|PRDATA[27]|PRDATA[28]|PRDATA[29]|PRDATA[31]|PRDATA[9]|PSLVERR|VGND
+ sky130_fd_pr__nfet_01v8 L=0.15 W=0.42 AS=0.1092 AD=0.0567 PS=1.36 PD=0.69
M$1336
+ LO|PRDATA[10]|PRDATA[12]|PRDATA[13]|PRDATA[15]|PRDATA[16]|PRDATA[17]|PRDATA[18]|PRDATA[19]|PRDATA[21]|PRDATA[23]|PRDATA[27]|PRDATA[28]|PRDATA[29]|PRDATA[31]|PRDATA[9]|PSLVERR|VGND
+ \$796 \$797
+ LO|PRDATA[10]|PRDATA[12]|PRDATA[13]|PRDATA[15]|PRDATA[16]|PRDATA[17]|PRDATA[18]|PRDATA[19]|PRDATA[21]|PRDATA[23]|PRDATA[27]|PRDATA[28]|PRDATA[29]|PRDATA[31]|PRDATA[9]|PSLVERR|VGND
+ sky130_fd_pr__nfet_01v8 L=0.15 W=0.42 AS=0.0567 AD=0.1092 PS=0.69 PD=1.36
M$1337
+ LO|PRDATA[10]|PRDATA[12]|PRDATA[13]|PRDATA[15]|PRDATA[16]|PRDATA[17]|PRDATA[18]|PRDATA[19]|PRDATA[21]|PRDATA[23]|PRDATA[27]|PRDATA[28]|PRDATA[29]|PRDATA[31]|PRDATA[9]|PSLVERR|VGND
+ D|X \$798
+ LO|PRDATA[10]|PRDATA[12]|PRDATA[13]|PRDATA[15]|PRDATA[16]|PRDATA[17]|PRDATA[18]|PRDATA[19]|PRDATA[21]|PRDATA[23]|PRDATA[27]|PRDATA[28]|PRDATA[29]|PRDATA[31]|PRDATA[9]|PSLVERR|VGND
+ sky130_fd_pr__nfet_01v8 L=0.15 W=0.42 AS=0.2205 AD=0.066 PS=1.89 PD=0.745
M$1338 \$798 \$796 \$799
+ LO|PRDATA[10]|PRDATA[12]|PRDATA[13]|PRDATA[15]|PRDATA[16]|PRDATA[17]|PRDATA[18]|PRDATA[19]|PRDATA[21]|PRDATA[23]|PRDATA[27]|PRDATA[28]|PRDATA[29]|PRDATA[31]|PRDATA[9]|PSLVERR|VGND
+ sky130_fd_pr__nfet_01v8 L=0.15 W=0.36 AS=0.066 AD=0.0594 PS=0.745 PD=0.69
M$1339 \$829 \$797 \$799
+ LO|PRDATA[10]|PRDATA[12]|PRDATA[13]|PRDATA[15]|PRDATA[16]|PRDATA[17]|PRDATA[18]|PRDATA[19]|PRDATA[21]|PRDATA[23]|PRDATA[27]|PRDATA[28]|PRDATA[29]|PRDATA[31]|PRDATA[9]|PSLVERR|VGND
+ sky130_fd_pr__nfet_01v8 L=0.15 W=0.36 AS=0.1401 AD=0.0594 PS=1.1 PD=0.69
M$1340 \$829 \$801 \$828
+ LO|PRDATA[10]|PRDATA[12]|PRDATA[13]|PRDATA[15]|PRDATA[16]|PRDATA[17]|PRDATA[18]|PRDATA[19]|PRDATA[21]|PRDATA[23]|PRDATA[27]|PRDATA[28]|PRDATA[29]|PRDATA[31]|PRDATA[9]|PSLVERR|VGND
+ sky130_fd_pr__nfet_01v8 L=0.15 W=0.42 AS=0.1401 AD=0.0441 PS=1.1 PD=0.63
M$1341
+ LO|PRDATA[10]|PRDATA[12]|PRDATA[13]|PRDATA[15]|PRDATA[16]|PRDATA[17]|PRDATA[18]|PRDATA[19]|PRDATA[21]|PRDATA[23]|PRDATA[27]|PRDATA[28]|PRDATA[29]|PRDATA[31]|PRDATA[9]|PSLVERR|VGND
+ PRESETn|RESET_B \$828
+ LO|PRDATA[10]|PRDATA[12]|PRDATA[13]|PRDATA[15]|PRDATA[16]|PRDATA[17]|PRDATA[18]|PRDATA[19]|PRDATA[21]|PRDATA[23]|PRDATA[27]|PRDATA[28]|PRDATA[29]|PRDATA[31]|PRDATA[9]|PSLVERR|VGND
+ sky130_fd_pr__nfet_01v8 L=0.15 W=0.42 AS=0.1346 AD=0.0441 PS=1.15 PD=0.63
M$1342
+ LO|PRDATA[10]|PRDATA[12]|PRDATA[13]|PRDATA[15]|PRDATA[16]|PRDATA[17]|PRDATA[18]|PRDATA[19]|PRDATA[21]|PRDATA[23]|PRDATA[27]|PRDATA[28]|PRDATA[29]|PRDATA[31]|PRDATA[9]|PSLVERR|VGND
+ \$799 \$801
+ LO|PRDATA[10]|PRDATA[12]|PRDATA[13]|PRDATA[15]|PRDATA[16]|PRDATA[17]|PRDATA[18]|PRDATA[19]|PRDATA[21]|PRDATA[23]|PRDATA[27]|PRDATA[28]|PRDATA[29]|PRDATA[31]|PRDATA[9]|PSLVERR|VGND
+ sky130_fd_pr__nfet_01v8 L=0.15 W=0.64 AS=0.1346 AD=0.0999 PS=1.15 PD=0.985
M$1343 \$801 \$797 \$802
+ LO|PRDATA[10]|PRDATA[12]|PRDATA[13]|PRDATA[15]|PRDATA[16]|PRDATA[17]|PRDATA[18]|PRDATA[19]|PRDATA[21]|PRDATA[23]|PRDATA[27]|PRDATA[28]|PRDATA[29]|PRDATA[31]|PRDATA[9]|PSLVERR|VGND
+ sky130_fd_pr__nfet_01v8 L=0.15 W=0.36 AS=0.0999 AD=0.0711 PS=0.985 PD=0.755
M$1344 \$827 \$796 \$802
+ LO|PRDATA[10]|PRDATA[12]|PRDATA[13]|PRDATA[15]|PRDATA[16]|PRDATA[17]|PRDATA[18]|PRDATA[19]|PRDATA[21]|PRDATA[23]|PRDATA[27]|PRDATA[28]|PRDATA[29]|PRDATA[31]|PRDATA[9]|PSLVERR|VGND
+ sky130_fd_pr__nfet_01v8 L=0.15 W=0.36 AS=0.0669 AD=0.0711 PS=0.75 PD=0.755
M$1345 \$827 \$818
+ LO|PRDATA[10]|PRDATA[12]|PRDATA[13]|PRDATA[15]|PRDATA[16]|PRDATA[17]|PRDATA[18]|PRDATA[19]|PRDATA[21]|PRDATA[23]|PRDATA[27]|PRDATA[28]|PRDATA[29]|PRDATA[31]|PRDATA[9]|PSLVERR|VGND
+ LO|PRDATA[10]|PRDATA[12]|PRDATA[13]|PRDATA[15]|PRDATA[16]|PRDATA[17]|PRDATA[18]|PRDATA[19]|PRDATA[21]|PRDATA[23]|PRDATA[27]|PRDATA[28]|PRDATA[29]|PRDATA[31]|PRDATA[9]|PSLVERR|VGND
+ sky130_fd_pr__nfet_01v8 L=0.15 W=0.42 AS=0.0669 AD=0.12495 PS=0.75 PD=1.015
M$1346
+ LO|PRDATA[10]|PRDATA[12]|PRDATA[13]|PRDATA[15]|PRDATA[16]|PRDATA[17]|PRDATA[18]|PRDATA[19]|PRDATA[21]|PRDATA[23]|PRDATA[27]|PRDATA[28]|PRDATA[29]|PRDATA[31]|PRDATA[9]|PSLVERR|VGND
+ PRESETn|RESET_B \$826
+ LO|PRDATA[10]|PRDATA[12]|PRDATA[13]|PRDATA[15]|PRDATA[16]|PRDATA[17]|PRDATA[18]|PRDATA[19]|PRDATA[21]|PRDATA[23]|PRDATA[27]|PRDATA[28]|PRDATA[29]|PRDATA[31]|PRDATA[9]|PSLVERR|VGND
+ sky130_fd_pr__nfet_01v8 L=0.15 W=0.42 AS=0.12495 AD=0.06405 PS=1.015 PD=0.725
M$1347 \$826 \$802 \$818
+ LO|PRDATA[10]|PRDATA[12]|PRDATA[13]|PRDATA[15]|PRDATA[16]|PRDATA[17]|PRDATA[18]|PRDATA[19]|PRDATA[21]|PRDATA[23]|PRDATA[27]|PRDATA[28]|PRDATA[29]|PRDATA[31]|PRDATA[9]|PSLVERR|VGND
+ sky130_fd_pr__nfet_01v8 L=0.15 W=0.42 AS=0.06405 AD=0.1092 PS=0.725 PD=1.36
M$1348
+ LO|PRDATA[10]|PRDATA[12]|PRDATA[13]|PRDATA[15]|PRDATA[16]|PRDATA[17]|PRDATA[18]|PRDATA[19]|PRDATA[21]|PRDATA[23]|PRDATA[27]|PRDATA[28]|PRDATA[29]|PRDATA[31]|PRDATA[9]|PSLVERR|VGND
+ \$818 A0|B2|Q|gpio_oe[5]
+ LO|PRDATA[10]|PRDATA[12]|PRDATA[13]|PRDATA[15]|PRDATA[16]|PRDATA[17]|PRDATA[18]|PRDATA[19]|PRDATA[21]|PRDATA[23]|PRDATA[27]|PRDATA[28]|PRDATA[29]|PRDATA[31]|PRDATA[9]|PSLVERR|VGND
+ sky130_fd_pr__nfet_01v8 L=0.15 W=0.65 AS=0.2087 AD=0.169 PS=2.02 PD=1.82
M$1349 A|X \$804
+ LO|PRDATA[10]|PRDATA[12]|PRDATA[13]|PRDATA[15]|PRDATA[16]|PRDATA[17]|PRDATA[18]|PRDATA[19]|PRDATA[21]|PRDATA[23]|PRDATA[27]|PRDATA[28]|PRDATA[29]|PRDATA[31]|PRDATA[9]|PSLVERR|VGND
+ LO|PRDATA[10]|PRDATA[12]|PRDATA[13]|PRDATA[15]|PRDATA[16]|PRDATA[17]|PRDATA[18]|PRDATA[19]|PRDATA[21]|PRDATA[23]|PRDATA[27]|PRDATA[28]|PRDATA[29]|PRDATA[31]|PRDATA[9]|PSLVERR|VGND
+ sky130_fd_pr__nfet_01v8 L=0.15 W=0.65 AS=0.169 AD=0.11285 PS=1.82 PD=1.045
M$1350
+ LO|PRDATA[10]|PRDATA[12]|PRDATA[13]|PRDATA[15]|PRDATA[16]|PRDATA[17]|PRDATA[18]|PRDATA[19]|PRDATA[21]|PRDATA[23]|PRDATA[27]|PRDATA[28]|PRDATA[29]|PRDATA[31]|PRDATA[9]|PSLVERR|VGND
+ S|X \$825
+ LO|PRDATA[10]|PRDATA[12]|PRDATA[13]|PRDATA[15]|PRDATA[16]|PRDATA[17]|PRDATA[18]|PRDATA[19]|PRDATA[21]|PRDATA[23]|PRDATA[27]|PRDATA[28]|PRDATA[29]|PRDATA[31]|PRDATA[9]|PSLVERR|VGND
+ sky130_fd_pr__nfet_01v8 L=0.15 W=0.42 AS=0.11285 AD=0.0693 PS=1.045 PD=0.75
M$1351 \$825 A1|PWDATA[4] \$804
+ LO|PRDATA[10]|PRDATA[12]|PRDATA[13]|PRDATA[15]|PRDATA[16]|PRDATA[17]|PRDATA[18]|PRDATA[19]|PRDATA[21]|PRDATA[23]|PRDATA[27]|PRDATA[28]|PRDATA[29]|PRDATA[31]|PRDATA[9]|PSLVERR|VGND
+ sky130_fd_pr__nfet_01v8 L=0.15 W=0.42 AS=0.0693 AD=0.09975 PS=0.75 PD=0.895
M$1352 \$804 A|A0|Q|gpio_oe[4] \$824
+ LO|PRDATA[10]|PRDATA[12]|PRDATA[13]|PRDATA[15]|PRDATA[16]|PRDATA[17]|PRDATA[18]|PRDATA[19]|PRDATA[21]|PRDATA[23]|PRDATA[27]|PRDATA[28]|PRDATA[29]|PRDATA[31]|PRDATA[9]|PSLVERR|VGND
+ sky130_fd_pr__nfet_01v8 L=0.15 W=0.42 AS=0.09975 AD=0.0693 PS=0.895 PD=0.75
M$1353 \$824 \$806
+ LO|PRDATA[10]|PRDATA[12]|PRDATA[13]|PRDATA[15]|PRDATA[16]|PRDATA[17]|PRDATA[18]|PRDATA[19]|PRDATA[21]|PRDATA[23]|PRDATA[27]|PRDATA[28]|PRDATA[29]|PRDATA[31]|PRDATA[9]|PSLVERR|VGND
+ LO|PRDATA[10]|PRDATA[12]|PRDATA[13]|PRDATA[15]|PRDATA[16]|PRDATA[17]|PRDATA[18]|PRDATA[19]|PRDATA[21]|PRDATA[23]|PRDATA[27]|PRDATA[28]|PRDATA[29]|PRDATA[31]|PRDATA[9]|PSLVERR|VGND
+ sky130_fd_pr__nfet_01v8 L=0.15 W=0.42 AS=0.0693 AD=0.1449 PS=0.75 PD=1.11
M$1354
+ LO|PRDATA[10]|PRDATA[12]|PRDATA[13]|PRDATA[15]|PRDATA[16]|PRDATA[17]|PRDATA[18]|PRDATA[19]|PRDATA[21]|PRDATA[23]|PRDATA[27]|PRDATA[28]|PRDATA[29]|PRDATA[31]|PRDATA[9]|PSLVERR|VGND
+ S|X \$806
+ LO|PRDATA[10]|PRDATA[12]|PRDATA[13]|PRDATA[15]|PRDATA[16]|PRDATA[17]|PRDATA[18]|PRDATA[19]|PRDATA[21]|PRDATA[23]|PRDATA[27]|PRDATA[28]|PRDATA[29]|PRDATA[31]|PRDATA[9]|PSLVERR|VGND
+ sky130_fd_pr__nfet_01v8 L=0.15 W=0.42 AS=0.1449 AD=0.1092 PS=1.11 PD=1.36
M$1355 \$808 S|X
+ LO|PRDATA[10]|PRDATA[12]|PRDATA[13]|PRDATA[15]|PRDATA[16]|PRDATA[17]|PRDATA[18]|PRDATA[19]|PRDATA[21]|PRDATA[23]|PRDATA[27]|PRDATA[28]|PRDATA[29]|PRDATA[31]|PRDATA[9]|PSLVERR|VGND
+ LO|PRDATA[10]|PRDATA[12]|PRDATA[13]|PRDATA[15]|PRDATA[16]|PRDATA[17]|PRDATA[18]|PRDATA[19]|PRDATA[21]|PRDATA[23]|PRDATA[27]|PRDATA[28]|PRDATA[29]|PRDATA[31]|PRDATA[9]|PSLVERR|VGND
+ sky130_fd_pr__nfet_01v8 L=0.15 W=0.65 AS=0.169 AD=0.108875 PS=1.82 PD=0.985
M$1356
+ LO|PRDATA[10]|PRDATA[12]|PRDATA[13]|PRDATA[15]|PRDATA[16]|PRDATA[17]|PRDATA[18]|PRDATA[19]|PRDATA[21]|PRDATA[23]|PRDATA[27]|PRDATA[28]|PRDATA[29]|PRDATA[31]|PRDATA[9]|PSLVERR|VGND
+ \$808 \$823
+ LO|PRDATA[10]|PRDATA[12]|PRDATA[13]|PRDATA[15]|PRDATA[16]|PRDATA[17]|PRDATA[18]|PRDATA[19]|PRDATA[21]|PRDATA[23]|PRDATA[27]|PRDATA[28]|PRDATA[29]|PRDATA[31]|PRDATA[9]|PSLVERR|VGND
+ sky130_fd_pr__nfet_01v8 L=0.15 W=0.65 AS=0.108875 AD=0.26 PS=0.985 PD=1.45
M$1357 \$823 A0|A1|Q|gpio_out[4] \$811
+ LO|PRDATA[10]|PRDATA[12]|PRDATA[13]|PRDATA[15]|PRDATA[16]|PRDATA[17]|PRDATA[18]|PRDATA[19]|PRDATA[21]|PRDATA[23]|PRDATA[27]|PRDATA[28]|PRDATA[29]|PRDATA[31]|PRDATA[9]|PSLVERR|VGND
+ sky130_fd_pr__nfet_01v8 L=0.15 W=0.65 AS=0.26 AD=0.104 PS=1.45 PD=0.97
M$1358 \$811 A1|PWDATA[4] \$822
+ LO|PRDATA[10]|PRDATA[12]|PRDATA[13]|PRDATA[15]|PRDATA[16]|PRDATA[17]|PRDATA[18]|PRDATA[19]|PRDATA[21]|PRDATA[23]|PRDATA[27]|PRDATA[28]|PRDATA[29]|PRDATA[31]|PRDATA[9]|PSLVERR|VGND
+ sky130_fd_pr__nfet_01v8 L=0.15 W=0.65 AS=0.104 AD=0.274625 PS=0.97 PD=1.495
M$1359 \$822 S|X
+ LO|PRDATA[10]|PRDATA[12]|PRDATA[13]|PRDATA[15]|PRDATA[16]|PRDATA[17]|PRDATA[18]|PRDATA[19]|PRDATA[21]|PRDATA[23]|PRDATA[27]|PRDATA[28]|PRDATA[29]|PRDATA[31]|PRDATA[9]|PSLVERR|VGND
+ LO|PRDATA[10]|PRDATA[12]|PRDATA[13]|PRDATA[15]|PRDATA[16]|PRDATA[17]|PRDATA[18]|PRDATA[19]|PRDATA[21]|PRDATA[23]|PRDATA[27]|PRDATA[28]|PRDATA[29]|PRDATA[31]|PRDATA[9]|PSLVERR|VGND
+ sky130_fd_pr__nfet_01v8 L=0.15 W=0.65 AS=0.274625 AD=0.08775 PS=1.495 PD=0.92
M$1360
+ LO|PRDATA[10]|PRDATA[12]|PRDATA[13]|PRDATA[15]|PRDATA[16]|PRDATA[17]|PRDATA[18]|PRDATA[19]|PRDATA[21]|PRDATA[23]|PRDATA[27]|PRDATA[28]|PRDATA[29]|PRDATA[31]|PRDATA[9]|PSLVERR|VGND
+ \$811 A|X
+ LO|PRDATA[10]|PRDATA[12]|PRDATA[13]|PRDATA[15]|PRDATA[16]|PRDATA[17]|PRDATA[18]|PRDATA[19]|PRDATA[21]|PRDATA[23]|PRDATA[27]|PRDATA[28]|PRDATA[29]|PRDATA[31]|PRDATA[9]|PSLVERR|VGND
+ sky130_fd_pr__nfet_01v8 L=0.15 W=2.6 AS=0.351 AD=0.43225 PS=3.68 PD=4.58
M$1364 \$834 A|X
+ LO|PRDATA[10]|PRDATA[12]|PRDATA[13]|PRDATA[15]|PRDATA[16]|PRDATA[17]|PRDATA[18]|PRDATA[19]|PRDATA[21]|PRDATA[23]|PRDATA[27]|PRDATA[28]|PRDATA[29]|PRDATA[31]|PRDATA[9]|PSLVERR|VGND
+ LO|PRDATA[10]|PRDATA[12]|PRDATA[13]|PRDATA[15]|PRDATA[16]|PRDATA[17]|PRDATA[18]|PRDATA[19]|PRDATA[21]|PRDATA[23]|PRDATA[27]|PRDATA[28]|PRDATA[29]|PRDATA[31]|PRDATA[9]|PSLVERR|VGND
+ sky130_fd_pr__nfet_01v8 L=0.15 W=0.65 AS=0.169 AD=0.08775 PS=1.82 PD=0.92
M$1365
+ LO|PRDATA[10]|PRDATA[12]|PRDATA[13]|PRDATA[15]|PRDATA[16]|PRDATA[17]|PRDATA[18]|PRDATA[19]|PRDATA[21]|PRDATA[23]|PRDATA[27]|PRDATA[28]|PRDATA[29]|PRDATA[31]|PRDATA[9]|PSLVERR|VGND
+ \$834 D|X
+ LO|PRDATA[10]|PRDATA[12]|PRDATA[13]|PRDATA[15]|PRDATA[16]|PRDATA[17]|PRDATA[18]|PRDATA[19]|PRDATA[21]|PRDATA[23]|PRDATA[27]|PRDATA[28]|PRDATA[29]|PRDATA[31]|PRDATA[9]|PSLVERR|VGND
+ sky130_fd_pr__nfet_01v8 L=0.15 W=2.6 AS=0.351 AD=0.43225 PS=3.68 PD=4.58
M$1369 \$836 S|X
+ LO|PRDATA[10]|PRDATA[12]|PRDATA[13]|PRDATA[15]|PRDATA[16]|PRDATA[17]|PRDATA[18]|PRDATA[19]|PRDATA[21]|PRDATA[23]|PRDATA[27]|PRDATA[28]|PRDATA[29]|PRDATA[31]|PRDATA[9]|PSLVERR|VGND
+ LO|PRDATA[10]|PRDATA[12]|PRDATA[13]|PRDATA[15]|PRDATA[16]|PRDATA[17]|PRDATA[18]|PRDATA[19]|PRDATA[21]|PRDATA[23]|PRDATA[27]|PRDATA[28]|PRDATA[29]|PRDATA[31]|PRDATA[9]|PSLVERR|VGND
+ sky130_fd_pr__nfet_01v8 L=0.15 W=0.65 AS=0.169 AD=0.108875 PS=1.82 PD=0.985
M$1370
+ LO|PRDATA[10]|PRDATA[12]|PRDATA[13]|PRDATA[15]|PRDATA[16]|PRDATA[17]|PRDATA[18]|PRDATA[19]|PRDATA[21]|PRDATA[23]|PRDATA[27]|PRDATA[28]|PRDATA[29]|PRDATA[31]|PRDATA[9]|PSLVERR|VGND
+ \$836 \$864
+ LO|PRDATA[10]|PRDATA[12]|PRDATA[13]|PRDATA[15]|PRDATA[16]|PRDATA[17]|PRDATA[18]|PRDATA[19]|PRDATA[21]|PRDATA[23]|PRDATA[27]|PRDATA[28]|PRDATA[29]|PRDATA[31]|PRDATA[9]|PSLVERR|VGND
+ sky130_fd_pr__nfet_01v8 L=0.15 W=0.65 AS=0.108875 AD=0.26 PS=0.985 PD=1.45
M$1371 \$864 A0|C1|Q|gpio_out[7] \$838
+ LO|PRDATA[10]|PRDATA[12]|PRDATA[13]|PRDATA[15]|PRDATA[16]|PRDATA[17]|PRDATA[18]|PRDATA[19]|PRDATA[21]|PRDATA[23]|PRDATA[27]|PRDATA[28]|PRDATA[29]|PRDATA[31]|PRDATA[9]|PSLVERR|VGND
+ sky130_fd_pr__nfet_01v8 L=0.15 W=0.65 AS=0.26 AD=0.104 PS=1.45 PD=0.97
M$1372 \$838 A1|PWDATA[7] \$865
+ LO|PRDATA[10]|PRDATA[12]|PRDATA[13]|PRDATA[15]|PRDATA[16]|PRDATA[17]|PRDATA[18]|PRDATA[19]|PRDATA[21]|PRDATA[23]|PRDATA[27]|PRDATA[28]|PRDATA[29]|PRDATA[31]|PRDATA[9]|PSLVERR|VGND
+ sky130_fd_pr__nfet_01v8 L=0.15 W=0.65 AS=0.104 AD=0.274625 PS=0.97 PD=1.495
M$1373 \$865 S|X
+ LO|PRDATA[10]|PRDATA[12]|PRDATA[13]|PRDATA[15]|PRDATA[16]|PRDATA[17]|PRDATA[18]|PRDATA[19]|PRDATA[21]|PRDATA[23]|PRDATA[27]|PRDATA[28]|PRDATA[29]|PRDATA[31]|PRDATA[9]|PSLVERR|VGND
+ LO|PRDATA[10]|PRDATA[12]|PRDATA[13]|PRDATA[15]|PRDATA[16]|PRDATA[17]|PRDATA[18]|PRDATA[19]|PRDATA[21]|PRDATA[23]|PRDATA[27]|PRDATA[28]|PRDATA[29]|PRDATA[31]|PRDATA[9]|PSLVERR|VGND
+ sky130_fd_pr__nfet_01v8 L=0.15 W=0.65 AS=0.274625 AD=0.08775 PS=1.495 PD=0.92
M$1374
+ LO|PRDATA[10]|PRDATA[12]|PRDATA[13]|PRDATA[15]|PRDATA[16]|PRDATA[17]|PRDATA[18]|PRDATA[19]|PRDATA[21]|PRDATA[23]|PRDATA[27]|PRDATA[28]|PRDATA[29]|PRDATA[31]|PRDATA[9]|PSLVERR|VGND
+ \$838 A|X
+ LO|PRDATA[10]|PRDATA[12]|PRDATA[13]|PRDATA[15]|PRDATA[16]|PRDATA[17]|PRDATA[18]|PRDATA[19]|PRDATA[21]|PRDATA[23]|PRDATA[27]|PRDATA[28]|PRDATA[29]|PRDATA[31]|PRDATA[9]|PSLVERR|VGND
+ sky130_fd_pr__nfet_01v8 L=0.15 W=2.6 AS=0.351 AD=0.43225 PS=3.68 PD=4.58
M$1378
+ LO|PRDATA[10]|PRDATA[12]|PRDATA[13]|PRDATA[15]|PRDATA[16]|PRDATA[17]|PRDATA[18]|PRDATA[19]|PRDATA[21]|PRDATA[23]|PRDATA[27]|PRDATA[28]|PRDATA[29]|PRDATA[31]|PRDATA[9]|PSLVERR|VGND
+ S|X \$870
+ LO|PRDATA[10]|PRDATA[12]|PRDATA[13]|PRDATA[15]|PRDATA[16]|PRDATA[17]|PRDATA[18]|PRDATA[19]|PRDATA[21]|PRDATA[23]|PRDATA[27]|PRDATA[28]|PRDATA[29]|PRDATA[31]|PRDATA[9]|PSLVERR|VGND
+ sky130_fd_pr__nfet_01v8 L=0.15 W=0.42 AS=0.11285 AD=0.0693 PS=1.045 PD=0.75
M$1379 \$870 A1|PWDATA[7] \$840
+ LO|PRDATA[10]|PRDATA[12]|PRDATA[13]|PRDATA[15]|PRDATA[16]|PRDATA[17]|PRDATA[18]|PRDATA[19]|PRDATA[21]|PRDATA[23]|PRDATA[27]|PRDATA[28]|PRDATA[29]|PRDATA[31]|PRDATA[9]|PSLVERR|VGND
+ sky130_fd_pr__nfet_01v8 L=0.15 W=0.42 AS=0.0693 AD=0.09975 PS=0.75 PD=0.895
M$1380 \$840 A0|B2|Q|gpio_oe[7] \$873
+ LO|PRDATA[10]|PRDATA[12]|PRDATA[13]|PRDATA[15]|PRDATA[16]|PRDATA[17]|PRDATA[18]|PRDATA[19]|PRDATA[21]|PRDATA[23]|PRDATA[27]|PRDATA[28]|PRDATA[29]|PRDATA[31]|PRDATA[9]|PSLVERR|VGND
+ sky130_fd_pr__nfet_01v8 L=0.15 W=0.42 AS=0.09975 AD=0.0693 PS=0.895 PD=0.75
M$1381 \$873 \$841
+ LO|PRDATA[10]|PRDATA[12]|PRDATA[13]|PRDATA[15]|PRDATA[16]|PRDATA[17]|PRDATA[18]|PRDATA[19]|PRDATA[21]|PRDATA[23]|PRDATA[27]|PRDATA[28]|PRDATA[29]|PRDATA[31]|PRDATA[9]|PSLVERR|VGND
+ LO|PRDATA[10]|PRDATA[12]|PRDATA[13]|PRDATA[15]|PRDATA[16]|PRDATA[17]|PRDATA[18]|PRDATA[19]|PRDATA[21]|PRDATA[23]|PRDATA[27]|PRDATA[28]|PRDATA[29]|PRDATA[31]|PRDATA[9]|PSLVERR|VGND
+ sky130_fd_pr__nfet_01v8 L=0.15 W=0.42 AS=0.0693 AD=0.1449 PS=0.75 PD=1.11
M$1382
+ LO|PRDATA[10]|PRDATA[12]|PRDATA[13]|PRDATA[15]|PRDATA[16]|PRDATA[17]|PRDATA[18]|PRDATA[19]|PRDATA[21]|PRDATA[23]|PRDATA[27]|PRDATA[28]|PRDATA[29]|PRDATA[31]|PRDATA[9]|PSLVERR|VGND
+ S|X \$841
+ LO|PRDATA[10]|PRDATA[12]|PRDATA[13]|PRDATA[15]|PRDATA[16]|PRDATA[17]|PRDATA[18]|PRDATA[19]|PRDATA[21]|PRDATA[23]|PRDATA[27]|PRDATA[28]|PRDATA[29]|PRDATA[31]|PRDATA[9]|PSLVERR|VGND
+ sky130_fd_pr__nfet_01v8 L=0.15 W=0.42 AS=0.1449 AD=0.1092 PS=1.11 PD=1.36
M$1383 A|X \$840
+ LO|PRDATA[10]|PRDATA[12]|PRDATA[13]|PRDATA[15]|PRDATA[16]|PRDATA[17]|PRDATA[18]|PRDATA[19]|PRDATA[21]|PRDATA[23]|PRDATA[27]|PRDATA[28]|PRDATA[29]|PRDATA[31]|PRDATA[9]|PSLVERR|VGND
+ LO|PRDATA[10]|PRDATA[12]|PRDATA[13]|PRDATA[15]|PRDATA[16]|PRDATA[17]|PRDATA[18]|PRDATA[19]|PRDATA[21]|PRDATA[23]|PRDATA[27]|PRDATA[28]|PRDATA[29]|PRDATA[31]|PRDATA[9]|PSLVERR|VGND
+ sky130_fd_pr__nfet_01v8 L=0.15 W=0.65 AS=0.169 AD=0.11285 PS=1.82 PD=1.045
M$1384
+ LO|PRDATA[10]|PRDATA[12]|PRDATA[13]|PRDATA[15]|PRDATA[16]|PRDATA[17]|PRDATA[18]|PRDATA[19]|PRDATA[21]|PRDATA[23]|PRDATA[27]|PRDATA[28]|PRDATA[29]|PRDATA[31]|PRDATA[9]|PSLVERR|VGND
+ \$915 A0|C1|Q|gpio_out[7]
+ LO|PRDATA[10]|PRDATA[12]|PRDATA[13]|PRDATA[15]|PRDATA[16]|PRDATA[17]|PRDATA[18]|PRDATA[19]|PRDATA[21]|PRDATA[23]|PRDATA[27]|PRDATA[28]|PRDATA[29]|PRDATA[31]|PRDATA[9]|PSLVERR|VGND
+ sky130_fd_pr__nfet_01v8 L=0.15 W=0.65 AS=0.2087 AD=0.169 PS=2.02 PD=1.82
M$1385 \$842 S|X
+ LO|PRDATA[10]|PRDATA[12]|PRDATA[13]|PRDATA[15]|PRDATA[16]|PRDATA[17]|PRDATA[18]|PRDATA[19]|PRDATA[21]|PRDATA[23]|PRDATA[27]|PRDATA[28]|PRDATA[29]|PRDATA[31]|PRDATA[9]|PSLVERR|VGND
+ LO|PRDATA[10]|PRDATA[12]|PRDATA[13]|PRDATA[15]|PRDATA[16]|PRDATA[17]|PRDATA[18]|PRDATA[19]|PRDATA[21]|PRDATA[23]|PRDATA[27]|PRDATA[28]|PRDATA[29]|PRDATA[31]|PRDATA[9]|PSLVERR|VGND
+ sky130_fd_pr__nfet_01v8 L=0.15 W=0.65 AS=0.169 AD=0.108875 PS=1.82 PD=0.985
M$1386
+ LO|PRDATA[10]|PRDATA[12]|PRDATA[13]|PRDATA[15]|PRDATA[16]|PRDATA[17]|PRDATA[18]|PRDATA[19]|PRDATA[21]|PRDATA[23]|PRDATA[27]|PRDATA[28]|PRDATA[29]|PRDATA[31]|PRDATA[9]|PSLVERR|VGND
+ \$842 \$881
+ LO|PRDATA[10]|PRDATA[12]|PRDATA[13]|PRDATA[15]|PRDATA[16]|PRDATA[17]|PRDATA[18]|PRDATA[19]|PRDATA[21]|PRDATA[23]|PRDATA[27]|PRDATA[28]|PRDATA[29]|PRDATA[31]|PRDATA[9]|PSLVERR|VGND
+ sky130_fd_pr__nfet_01v8 L=0.15 W=0.65 AS=0.108875 AD=0.26 PS=0.985 PD=1.45
M$1387 \$881 A0|C1|Q|gpio_out[5] \$844
+ LO|PRDATA[10]|PRDATA[12]|PRDATA[13]|PRDATA[15]|PRDATA[16]|PRDATA[17]|PRDATA[18]|PRDATA[19]|PRDATA[21]|PRDATA[23]|PRDATA[27]|PRDATA[28]|PRDATA[29]|PRDATA[31]|PRDATA[9]|PSLVERR|VGND
+ sky130_fd_pr__nfet_01v8 L=0.15 W=0.65 AS=0.26 AD=0.104 PS=1.45 PD=0.97
M$1388 \$844 A1|PWDATA[5] \$882
+ LO|PRDATA[10]|PRDATA[12]|PRDATA[13]|PRDATA[15]|PRDATA[16]|PRDATA[17]|PRDATA[18]|PRDATA[19]|PRDATA[21]|PRDATA[23]|PRDATA[27]|PRDATA[28]|PRDATA[29]|PRDATA[31]|PRDATA[9]|PSLVERR|VGND
+ sky130_fd_pr__nfet_01v8 L=0.15 W=0.65 AS=0.104 AD=0.274625 PS=0.97 PD=1.495
M$1389 \$882 S|X
+ LO|PRDATA[10]|PRDATA[12]|PRDATA[13]|PRDATA[15]|PRDATA[16]|PRDATA[17]|PRDATA[18]|PRDATA[19]|PRDATA[21]|PRDATA[23]|PRDATA[27]|PRDATA[28]|PRDATA[29]|PRDATA[31]|PRDATA[9]|PSLVERR|VGND
+ LO|PRDATA[10]|PRDATA[12]|PRDATA[13]|PRDATA[15]|PRDATA[16]|PRDATA[17]|PRDATA[18]|PRDATA[19]|PRDATA[21]|PRDATA[23]|PRDATA[27]|PRDATA[28]|PRDATA[29]|PRDATA[31]|PRDATA[9]|PSLVERR|VGND
+ sky130_fd_pr__nfet_01v8 L=0.15 W=0.65 AS=0.274625 AD=0.08775 PS=1.495 PD=0.92
M$1390
+ LO|PRDATA[10]|PRDATA[12]|PRDATA[13]|PRDATA[15]|PRDATA[16]|PRDATA[17]|PRDATA[18]|PRDATA[19]|PRDATA[21]|PRDATA[23]|PRDATA[27]|PRDATA[28]|PRDATA[29]|PRDATA[31]|PRDATA[9]|PSLVERR|VGND
+ \$844 A|X
+ LO|PRDATA[10]|PRDATA[12]|PRDATA[13]|PRDATA[15]|PRDATA[16]|PRDATA[17]|PRDATA[18]|PRDATA[19]|PRDATA[21]|PRDATA[23]|PRDATA[27]|PRDATA[28]|PRDATA[29]|PRDATA[31]|PRDATA[9]|PSLVERR|VGND
+ sky130_fd_pr__nfet_01v8 L=0.15 W=2.6 AS=0.351 AD=0.43225 PS=3.68 PD=4.58
M$1394 A|X \$918
+ LO|PRDATA[10]|PRDATA[12]|PRDATA[13]|PRDATA[15]|PRDATA[16]|PRDATA[17]|PRDATA[18]|PRDATA[19]|PRDATA[21]|PRDATA[23]|PRDATA[27]|PRDATA[28]|PRDATA[29]|PRDATA[31]|PRDATA[9]|PSLVERR|VGND
+ LO|PRDATA[10]|PRDATA[12]|PRDATA[13]|PRDATA[15]|PRDATA[16]|PRDATA[17]|PRDATA[18]|PRDATA[19]|PRDATA[21]|PRDATA[23]|PRDATA[27]|PRDATA[28]|PRDATA[29]|PRDATA[31]|PRDATA[9]|PSLVERR|VGND
+ sky130_fd_pr__nfet_01v8 L=0.15 W=0.65 AS=0.169 AD=0.11285 PS=1.82 PD=1.045
M$1395
+ LO|PRDATA[10]|PRDATA[12]|PRDATA[13]|PRDATA[15]|PRDATA[16]|PRDATA[17]|PRDATA[18]|PRDATA[19]|PRDATA[21]|PRDATA[23]|PRDATA[27]|PRDATA[28]|PRDATA[29]|PRDATA[31]|PRDATA[9]|PSLVERR|VGND
+ S|X \$944
+ LO|PRDATA[10]|PRDATA[12]|PRDATA[13]|PRDATA[15]|PRDATA[16]|PRDATA[17]|PRDATA[18]|PRDATA[19]|PRDATA[21]|PRDATA[23]|PRDATA[27]|PRDATA[28]|PRDATA[29]|PRDATA[31]|PRDATA[9]|PSLVERR|VGND
+ sky130_fd_pr__nfet_01v8 L=0.15 W=0.42 AS=0.11285 AD=0.0693 PS=1.045 PD=0.75
M$1396 \$944 A1|PWDATA[5] \$918
+ LO|PRDATA[10]|PRDATA[12]|PRDATA[13]|PRDATA[15]|PRDATA[16]|PRDATA[17]|PRDATA[18]|PRDATA[19]|PRDATA[21]|PRDATA[23]|PRDATA[27]|PRDATA[28]|PRDATA[29]|PRDATA[31]|PRDATA[9]|PSLVERR|VGND
+ sky130_fd_pr__nfet_01v8 L=0.15 W=0.42 AS=0.0693 AD=0.09975 PS=0.75 PD=0.895
M$1397 \$918 A0|B2|Q|gpio_oe[5] \$942
+ LO|PRDATA[10]|PRDATA[12]|PRDATA[13]|PRDATA[15]|PRDATA[16]|PRDATA[17]|PRDATA[18]|PRDATA[19]|PRDATA[21]|PRDATA[23]|PRDATA[27]|PRDATA[28]|PRDATA[29]|PRDATA[31]|PRDATA[9]|PSLVERR|VGND
+ sky130_fd_pr__nfet_01v8 L=0.15 W=0.42 AS=0.09975 AD=0.0693 PS=0.895 PD=0.75
M$1398 \$942 \$919
+ LO|PRDATA[10]|PRDATA[12]|PRDATA[13]|PRDATA[15]|PRDATA[16]|PRDATA[17]|PRDATA[18]|PRDATA[19]|PRDATA[21]|PRDATA[23]|PRDATA[27]|PRDATA[28]|PRDATA[29]|PRDATA[31]|PRDATA[9]|PSLVERR|VGND
+ LO|PRDATA[10]|PRDATA[12]|PRDATA[13]|PRDATA[15]|PRDATA[16]|PRDATA[17]|PRDATA[18]|PRDATA[19]|PRDATA[21]|PRDATA[23]|PRDATA[27]|PRDATA[28]|PRDATA[29]|PRDATA[31]|PRDATA[9]|PSLVERR|VGND
+ sky130_fd_pr__nfet_01v8 L=0.15 W=0.42 AS=0.0693 AD=0.1449 PS=0.75 PD=1.11
M$1399
+ LO|PRDATA[10]|PRDATA[12]|PRDATA[13]|PRDATA[15]|PRDATA[16]|PRDATA[17]|PRDATA[18]|PRDATA[19]|PRDATA[21]|PRDATA[23]|PRDATA[27]|PRDATA[28]|PRDATA[29]|PRDATA[31]|PRDATA[9]|PSLVERR|VGND
+ S|X \$919
+ LO|PRDATA[10]|PRDATA[12]|PRDATA[13]|PRDATA[15]|PRDATA[16]|PRDATA[17]|PRDATA[18]|PRDATA[19]|PRDATA[21]|PRDATA[23]|PRDATA[27]|PRDATA[28]|PRDATA[29]|PRDATA[31]|PRDATA[9]|PSLVERR|VGND
+ sky130_fd_pr__nfet_01v8 L=0.15 W=0.42 AS=0.1449 AD=0.1092 PS=1.11 PD=1.36
M$1400 \$846 CLK|X
+ LO|PRDATA[10]|PRDATA[12]|PRDATA[13]|PRDATA[15]|PRDATA[16]|PRDATA[17]|PRDATA[18]|PRDATA[19]|PRDATA[21]|PRDATA[23]|PRDATA[27]|PRDATA[28]|PRDATA[29]|PRDATA[31]|PRDATA[9]|PSLVERR|VGND
+ LO|PRDATA[10]|PRDATA[12]|PRDATA[13]|PRDATA[15]|PRDATA[16]|PRDATA[17]|PRDATA[18]|PRDATA[19]|PRDATA[21]|PRDATA[23]|PRDATA[27]|PRDATA[28]|PRDATA[29]|PRDATA[31]|PRDATA[9]|PSLVERR|VGND
+ sky130_fd_pr__nfet_01v8 L=0.15 W=0.42 AS=0.1092 AD=0.0567 PS=1.36 PD=0.69
M$1401
+ LO|PRDATA[10]|PRDATA[12]|PRDATA[13]|PRDATA[15]|PRDATA[16]|PRDATA[17]|PRDATA[18]|PRDATA[19]|PRDATA[21]|PRDATA[23]|PRDATA[27]|PRDATA[28]|PRDATA[29]|PRDATA[31]|PRDATA[9]|PSLVERR|VGND
+ \$846 \$847
+ LO|PRDATA[10]|PRDATA[12]|PRDATA[13]|PRDATA[15]|PRDATA[16]|PRDATA[17]|PRDATA[18]|PRDATA[19]|PRDATA[21]|PRDATA[23]|PRDATA[27]|PRDATA[28]|PRDATA[29]|PRDATA[31]|PRDATA[9]|PSLVERR|VGND
+ sky130_fd_pr__nfet_01v8 L=0.15 W=0.42 AS=0.0567 AD=0.1092 PS=0.69 PD=1.36
M$1402
+ LO|PRDATA[10]|PRDATA[12]|PRDATA[13]|PRDATA[15]|PRDATA[16]|PRDATA[17]|PRDATA[18]|PRDATA[19]|PRDATA[21]|PRDATA[23]|PRDATA[27]|PRDATA[28]|PRDATA[29]|PRDATA[31]|PRDATA[9]|PSLVERR|VGND
+ B2|gpio_in[4] \$935
+ LO|PRDATA[10]|PRDATA[12]|PRDATA[13]|PRDATA[15]|PRDATA[16]|PRDATA[17]|PRDATA[18]|PRDATA[19]|PRDATA[21]|PRDATA[23]|PRDATA[27]|PRDATA[28]|PRDATA[29]|PRDATA[31]|PRDATA[9]|PSLVERR|VGND
+ sky130_fd_pr__nfet_01v8 L=0.15 W=0.65 AS=0.169 AD=0.07475 PS=1.82 PD=0.88
M$1403 \$935 A2|B1|Y A2|Y
+ LO|PRDATA[10]|PRDATA[12]|PRDATA[13]|PRDATA[15]|PRDATA[16]|PRDATA[17]|PRDATA[18]|PRDATA[19]|PRDATA[21]|PRDATA[23]|PRDATA[27]|PRDATA[28]|PRDATA[29]|PRDATA[31]|PRDATA[9]|PSLVERR|VGND
+ sky130_fd_pr__nfet_01v8 L=0.15 W=0.65 AS=0.07475 AD=0.169 PS=0.88 PD=1.82
M$1404 \$848 \$846 \$849
+ LO|PRDATA[10]|PRDATA[12]|PRDATA[13]|PRDATA[15]|PRDATA[16]|PRDATA[17]|PRDATA[18]|PRDATA[19]|PRDATA[21]|PRDATA[23]|PRDATA[27]|PRDATA[28]|PRDATA[29]|PRDATA[31]|PRDATA[9]|PSLVERR|VGND
+ sky130_fd_pr__nfet_01v8 L=0.15 W=0.36 AS=0.066 AD=0.0594 PS=0.745 PD=0.69
M$1405 \$849 \$847 \$893
+ LO|PRDATA[10]|PRDATA[12]|PRDATA[13]|PRDATA[15]|PRDATA[16]|PRDATA[17]|PRDATA[18]|PRDATA[19]|PRDATA[21]|PRDATA[23]|PRDATA[27]|PRDATA[28]|PRDATA[29]|PRDATA[31]|PRDATA[9]|PSLVERR|VGND
+ sky130_fd_pr__nfet_01v8 L=0.15 W=0.36 AS=0.0594 AD=0.1401 PS=0.69 PD=1.1
M$1406 \$897 \$847 \$850
+ LO|PRDATA[10]|PRDATA[12]|PRDATA[13]|PRDATA[15]|PRDATA[16]|PRDATA[17]|PRDATA[18]|PRDATA[19]|PRDATA[21]|PRDATA[23]|PRDATA[27]|PRDATA[28]|PRDATA[29]|PRDATA[31]|PRDATA[9]|PSLVERR|VGND
+ sky130_fd_pr__nfet_01v8 L=0.15 W=0.36 AS=0.0999 AD=0.0711 PS=0.985 PD=0.755
M$1407 \$850 \$846 \$895
+ LO|PRDATA[10]|PRDATA[12]|PRDATA[13]|PRDATA[15]|PRDATA[16]|PRDATA[17]|PRDATA[18]|PRDATA[19]|PRDATA[21]|PRDATA[23]|PRDATA[27]|PRDATA[28]|PRDATA[29]|PRDATA[31]|PRDATA[9]|PSLVERR|VGND
+ sky130_fd_pr__nfet_01v8 L=0.15 W=0.36 AS=0.0711 AD=0.0669 PS=0.755 PD=0.75
M$1408
+ LO|PRDATA[10]|PRDATA[12]|PRDATA[13]|PRDATA[15]|PRDATA[16]|PRDATA[17]|PRDATA[18]|PRDATA[19]|PRDATA[21]|PRDATA[23]|PRDATA[27]|PRDATA[28]|PRDATA[29]|PRDATA[31]|PRDATA[9]|PSLVERR|VGND
+ D|X \$848
+ LO|PRDATA[10]|PRDATA[12]|PRDATA[13]|PRDATA[15]|PRDATA[16]|PRDATA[17]|PRDATA[18]|PRDATA[19]|PRDATA[21]|PRDATA[23]|PRDATA[27]|PRDATA[28]|PRDATA[29]|PRDATA[31]|PRDATA[9]|PSLVERR|VGND
+ sky130_fd_pr__nfet_01v8 L=0.15 W=0.42 AS=0.2205 AD=0.066 PS=1.89 PD=0.745
M$1409 \$893 \$897 \$894
+ LO|PRDATA[10]|PRDATA[12]|PRDATA[13]|PRDATA[15]|PRDATA[16]|PRDATA[17]|PRDATA[18]|PRDATA[19]|PRDATA[21]|PRDATA[23]|PRDATA[27]|PRDATA[28]|PRDATA[29]|PRDATA[31]|PRDATA[9]|PSLVERR|VGND
+ sky130_fd_pr__nfet_01v8 L=0.15 W=0.42 AS=0.1401 AD=0.0441 PS=1.1 PD=0.63
M$1410 \$894 PRESETn|RESET_B
+ LO|PRDATA[10]|PRDATA[12]|PRDATA[13]|PRDATA[15]|PRDATA[16]|PRDATA[17]|PRDATA[18]|PRDATA[19]|PRDATA[21]|PRDATA[23]|PRDATA[27]|PRDATA[28]|PRDATA[29]|PRDATA[31]|PRDATA[9]|PSLVERR|VGND
+ LO|PRDATA[10]|PRDATA[12]|PRDATA[13]|PRDATA[15]|PRDATA[16]|PRDATA[17]|PRDATA[18]|PRDATA[19]|PRDATA[21]|PRDATA[23]|PRDATA[27]|PRDATA[28]|PRDATA[29]|PRDATA[31]|PRDATA[9]|PSLVERR|VGND
+ sky130_fd_pr__nfet_01v8 L=0.15 W=0.42 AS=0.0441 AD=0.1346 PS=0.63 PD=1.15
M$1411 \$895 \$851
+ LO|PRDATA[10]|PRDATA[12]|PRDATA[13]|PRDATA[15]|PRDATA[16]|PRDATA[17]|PRDATA[18]|PRDATA[19]|PRDATA[21]|PRDATA[23]|PRDATA[27]|PRDATA[28]|PRDATA[29]|PRDATA[31]|PRDATA[9]|PSLVERR|VGND
+ LO|PRDATA[10]|PRDATA[12]|PRDATA[13]|PRDATA[15]|PRDATA[16]|PRDATA[17]|PRDATA[18]|PRDATA[19]|PRDATA[21]|PRDATA[23]|PRDATA[27]|PRDATA[28]|PRDATA[29]|PRDATA[31]|PRDATA[9]|PSLVERR|VGND
+ sky130_fd_pr__nfet_01v8 L=0.15 W=0.42 AS=0.0669 AD=0.12495 PS=0.75 PD=1.015
M$1412
+ LO|PRDATA[10]|PRDATA[12]|PRDATA[13]|PRDATA[15]|PRDATA[16]|PRDATA[17]|PRDATA[18]|PRDATA[19]|PRDATA[21]|PRDATA[23]|PRDATA[27]|PRDATA[28]|PRDATA[29]|PRDATA[31]|PRDATA[9]|PSLVERR|VGND
+ PRESETn|RESET_B \$892
+ LO|PRDATA[10]|PRDATA[12]|PRDATA[13]|PRDATA[15]|PRDATA[16]|PRDATA[17]|PRDATA[18]|PRDATA[19]|PRDATA[21]|PRDATA[23]|PRDATA[27]|PRDATA[28]|PRDATA[29]|PRDATA[31]|PRDATA[9]|PSLVERR|VGND
+ sky130_fd_pr__nfet_01v8 L=0.15 W=0.42 AS=0.12495 AD=0.06405 PS=1.015 PD=0.725
M$1413 \$892 \$850 \$851
+ LO|PRDATA[10]|PRDATA[12]|PRDATA[13]|PRDATA[15]|PRDATA[16]|PRDATA[17]|PRDATA[18]|PRDATA[19]|PRDATA[21]|PRDATA[23]|PRDATA[27]|PRDATA[28]|PRDATA[29]|PRDATA[31]|PRDATA[9]|PSLVERR|VGND
+ sky130_fd_pr__nfet_01v8 L=0.15 W=0.42 AS=0.06405 AD=0.1092 PS=0.725 PD=1.36
M$1414
+ LO|PRDATA[10]|PRDATA[12]|PRDATA[13]|PRDATA[15]|PRDATA[16]|PRDATA[17]|PRDATA[18]|PRDATA[19]|PRDATA[21]|PRDATA[23]|PRDATA[27]|PRDATA[28]|PRDATA[29]|PRDATA[31]|PRDATA[9]|PSLVERR|VGND
+ \$849 \$897
+ LO|PRDATA[10]|PRDATA[12]|PRDATA[13]|PRDATA[15]|PRDATA[16]|PRDATA[17]|PRDATA[18]|PRDATA[19]|PRDATA[21]|PRDATA[23]|PRDATA[27]|PRDATA[28]|PRDATA[29]|PRDATA[31]|PRDATA[9]|PSLVERR|VGND
+ sky130_fd_pr__nfet_01v8 L=0.15 W=0.64 AS=0.1346 AD=0.0999 PS=1.15 PD=0.985
M$1415 A2|Y A0|A1|Q|gpio_out[4] \$934
+ LO|PRDATA[10]|PRDATA[12]|PRDATA[13]|PRDATA[15]|PRDATA[16]|PRDATA[17]|PRDATA[18]|PRDATA[19]|PRDATA[21]|PRDATA[23]|PRDATA[27]|PRDATA[28]|PRDATA[29]|PRDATA[31]|PRDATA[9]|PSLVERR|VGND
+ sky130_fd_pr__nfet_01v8 L=0.15 W=0.65 AS=0.169 AD=0.06825 PS=1.82 PD=0.86
M$1416 \$934 A2|B|C2|Y
+ LO|PRDATA[10]|PRDATA[12]|PRDATA[13]|PRDATA[15]|PRDATA[16]|PRDATA[17]|PRDATA[18]|PRDATA[19]|PRDATA[21]|PRDATA[23]|PRDATA[27]|PRDATA[28]|PRDATA[29]|PRDATA[31]|PRDATA[9]|PSLVERR|VGND
+ LO|PRDATA[10]|PRDATA[12]|PRDATA[13]|PRDATA[15]|PRDATA[16]|PRDATA[17]|PRDATA[18]|PRDATA[19]|PRDATA[21]|PRDATA[23]|PRDATA[27]|PRDATA[28]|PRDATA[29]|PRDATA[31]|PRDATA[9]|PSLVERR|VGND
+ sky130_fd_pr__nfet_01v8 L=0.15 W=0.65 AS=0.06825 AD=0.234 PS=0.86 PD=2.02
M$1417
+ LO|PRDATA[10]|PRDATA[12]|PRDATA[13]|PRDATA[15]|PRDATA[16]|PRDATA[17]|PRDATA[18]|PRDATA[19]|PRDATA[21]|PRDATA[23]|PRDATA[27]|PRDATA[28]|PRDATA[29]|PRDATA[31]|PRDATA[9]|PSLVERR|VGND
+ A|X \$924
+ LO|PRDATA[10]|PRDATA[12]|PRDATA[13]|PRDATA[15]|PRDATA[16]|PRDATA[17]|PRDATA[18]|PRDATA[19]|PRDATA[21]|PRDATA[23]|PRDATA[27]|PRDATA[28]|PRDATA[29]|PRDATA[31]|PRDATA[9]|PSLVERR|VGND
+ sky130_fd_pr__nfet_01v8 L=0.15 W=1.3 AS=0.25675 AD=0.1755 PS=2.74 PD=1.84
M$1419
+ LO|PRDATA[10]|PRDATA[12]|PRDATA[13]|PRDATA[15]|PRDATA[16]|PRDATA[17]|PRDATA[18]|PRDATA[19]|PRDATA[21]|PRDATA[23]|PRDATA[27]|PRDATA[28]|PRDATA[29]|PRDATA[31]|PRDATA[9]|PSLVERR|VGND
+ \$924 D|X
+ LO|PRDATA[10]|PRDATA[12]|PRDATA[13]|PRDATA[15]|PRDATA[16]|PRDATA[17]|PRDATA[18]|PRDATA[19]|PRDATA[21]|PRDATA[23]|PRDATA[27]|PRDATA[28]|PRDATA[29]|PRDATA[31]|PRDATA[9]|PSLVERR|VGND
+ sky130_fd_pr__nfet_01v8 L=0.15 W=3.9 AS=0.5265 AD=0.60775 PS=5.52 PD=6.42
M$1425
+ LO|PRDATA[10]|PRDATA[12]|PRDATA[13]|PRDATA[15]|PRDATA[16]|PRDATA[17]|PRDATA[18]|PRDATA[19]|PRDATA[21]|PRDATA[23]|PRDATA[27]|PRDATA[28]|PRDATA[29]|PRDATA[31]|PRDATA[9]|PSLVERR|VGND
+ \$851 A0|A1|Q|gpio_out[4]
+ LO|PRDATA[10]|PRDATA[12]|PRDATA[13]|PRDATA[15]|PRDATA[16]|PRDATA[17]|PRDATA[18]|PRDATA[19]|PRDATA[21]|PRDATA[23]|PRDATA[27]|PRDATA[28]|PRDATA[29]|PRDATA[31]|PRDATA[9]|PSLVERR|VGND
+ sky130_fd_pr__nfet_01v8 L=0.15 W=0.65 AS=0.2087 AD=0.169 PS=2.02 PD=1.82
M$1426 \$908 CLK|X
+ LO|PRDATA[10]|PRDATA[12]|PRDATA[13]|PRDATA[15]|PRDATA[16]|PRDATA[17]|PRDATA[18]|PRDATA[19]|PRDATA[21]|PRDATA[23]|PRDATA[27]|PRDATA[28]|PRDATA[29]|PRDATA[31]|PRDATA[9]|PSLVERR|VGND
+ LO|PRDATA[10]|PRDATA[12]|PRDATA[13]|PRDATA[15]|PRDATA[16]|PRDATA[17]|PRDATA[18]|PRDATA[19]|PRDATA[21]|PRDATA[23]|PRDATA[27]|PRDATA[28]|PRDATA[29]|PRDATA[31]|PRDATA[9]|PSLVERR|VGND
+ sky130_fd_pr__nfet_01v8 L=0.15 W=0.42 AS=0.1092 AD=0.0567 PS=1.36 PD=0.69
M$1427
+ LO|PRDATA[10]|PRDATA[12]|PRDATA[13]|PRDATA[15]|PRDATA[16]|PRDATA[17]|PRDATA[18]|PRDATA[19]|PRDATA[21]|PRDATA[23]|PRDATA[27]|PRDATA[28]|PRDATA[29]|PRDATA[31]|PRDATA[9]|PSLVERR|VGND
+ \$908 \$909
+ LO|PRDATA[10]|PRDATA[12]|PRDATA[13]|PRDATA[15]|PRDATA[16]|PRDATA[17]|PRDATA[18]|PRDATA[19]|PRDATA[21]|PRDATA[23]|PRDATA[27]|PRDATA[28]|PRDATA[29]|PRDATA[31]|PRDATA[9]|PSLVERR|VGND
+ sky130_fd_pr__nfet_01v8 L=0.15 W=0.42 AS=0.0567 AD=0.1092 PS=0.69 PD=1.36
M$1428
+ LO|PRDATA[10]|PRDATA[12]|PRDATA[13]|PRDATA[15]|PRDATA[16]|PRDATA[17]|PRDATA[18]|PRDATA[19]|PRDATA[21]|PRDATA[23]|PRDATA[27]|PRDATA[28]|PRDATA[29]|PRDATA[31]|PRDATA[9]|PSLVERR|VGND
+ D|X \$910
+ LO|PRDATA[10]|PRDATA[12]|PRDATA[13]|PRDATA[15]|PRDATA[16]|PRDATA[17]|PRDATA[18]|PRDATA[19]|PRDATA[21]|PRDATA[23]|PRDATA[27]|PRDATA[28]|PRDATA[29]|PRDATA[31]|PRDATA[9]|PSLVERR|VGND
+ sky130_fd_pr__nfet_01v8 L=0.15 W=0.42 AS=0.2205 AD=0.066 PS=1.89 PD=0.745
M$1429 \$910 \$908 \$911
+ LO|PRDATA[10]|PRDATA[12]|PRDATA[13]|PRDATA[15]|PRDATA[16]|PRDATA[17]|PRDATA[18]|PRDATA[19]|PRDATA[21]|PRDATA[23]|PRDATA[27]|PRDATA[28]|PRDATA[29]|PRDATA[31]|PRDATA[9]|PSLVERR|VGND
+ sky130_fd_pr__nfet_01v8 L=0.15 W=0.36 AS=0.066 AD=0.0594 PS=0.745 PD=0.69
M$1430 \$943 \$909 \$911
+ LO|PRDATA[10]|PRDATA[12]|PRDATA[13]|PRDATA[15]|PRDATA[16]|PRDATA[17]|PRDATA[18]|PRDATA[19]|PRDATA[21]|PRDATA[23]|PRDATA[27]|PRDATA[28]|PRDATA[29]|PRDATA[31]|PRDATA[9]|PSLVERR|VGND
+ sky130_fd_pr__nfet_01v8 L=0.15 W=0.36 AS=0.1401 AD=0.0594 PS=1.1 PD=0.69
M$1431 \$943 \$913 \$941
+ LO|PRDATA[10]|PRDATA[12]|PRDATA[13]|PRDATA[15]|PRDATA[16]|PRDATA[17]|PRDATA[18]|PRDATA[19]|PRDATA[21]|PRDATA[23]|PRDATA[27]|PRDATA[28]|PRDATA[29]|PRDATA[31]|PRDATA[9]|PSLVERR|VGND
+ sky130_fd_pr__nfet_01v8 L=0.15 W=0.42 AS=0.1401 AD=0.0441 PS=1.1 PD=0.63
M$1432
+ LO|PRDATA[10]|PRDATA[12]|PRDATA[13]|PRDATA[15]|PRDATA[16]|PRDATA[17]|PRDATA[18]|PRDATA[19]|PRDATA[21]|PRDATA[23]|PRDATA[27]|PRDATA[28]|PRDATA[29]|PRDATA[31]|PRDATA[9]|PSLVERR|VGND
+ PRESETn|RESET_B \$941
+ LO|PRDATA[10]|PRDATA[12]|PRDATA[13]|PRDATA[15]|PRDATA[16]|PRDATA[17]|PRDATA[18]|PRDATA[19]|PRDATA[21]|PRDATA[23]|PRDATA[27]|PRDATA[28]|PRDATA[29]|PRDATA[31]|PRDATA[9]|PSLVERR|VGND
+ sky130_fd_pr__nfet_01v8 L=0.15 W=0.42 AS=0.1346 AD=0.0441 PS=1.15 PD=0.63
M$1433
+ LO|PRDATA[10]|PRDATA[12]|PRDATA[13]|PRDATA[15]|PRDATA[16]|PRDATA[17]|PRDATA[18]|PRDATA[19]|PRDATA[21]|PRDATA[23]|PRDATA[27]|PRDATA[28]|PRDATA[29]|PRDATA[31]|PRDATA[9]|PSLVERR|VGND
+ \$911 \$913
+ LO|PRDATA[10]|PRDATA[12]|PRDATA[13]|PRDATA[15]|PRDATA[16]|PRDATA[17]|PRDATA[18]|PRDATA[19]|PRDATA[21]|PRDATA[23]|PRDATA[27]|PRDATA[28]|PRDATA[29]|PRDATA[31]|PRDATA[9]|PSLVERR|VGND
+ sky130_fd_pr__nfet_01v8 L=0.15 W=0.64 AS=0.1346 AD=0.0999 PS=1.15 PD=0.985
M$1434 \$913 \$909 \$914
+ LO|PRDATA[10]|PRDATA[12]|PRDATA[13]|PRDATA[15]|PRDATA[16]|PRDATA[17]|PRDATA[18]|PRDATA[19]|PRDATA[21]|PRDATA[23]|PRDATA[27]|PRDATA[28]|PRDATA[29]|PRDATA[31]|PRDATA[9]|PSLVERR|VGND
+ sky130_fd_pr__nfet_01v8 L=0.15 W=0.36 AS=0.0999 AD=0.0711 PS=0.985 PD=0.755
M$1435 \$945 \$908 \$914
+ LO|PRDATA[10]|PRDATA[12]|PRDATA[13]|PRDATA[15]|PRDATA[16]|PRDATA[17]|PRDATA[18]|PRDATA[19]|PRDATA[21]|PRDATA[23]|PRDATA[27]|PRDATA[28]|PRDATA[29]|PRDATA[31]|PRDATA[9]|PSLVERR|VGND
+ sky130_fd_pr__nfet_01v8 L=0.15 W=0.36 AS=0.0669 AD=0.0711 PS=0.75 PD=0.755
M$1436 \$945 \$915
+ LO|PRDATA[10]|PRDATA[12]|PRDATA[13]|PRDATA[15]|PRDATA[16]|PRDATA[17]|PRDATA[18]|PRDATA[19]|PRDATA[21]|PRDATA[23]|PRDATA[27]|PRDATA[28]|PRDATA[29]|PRDATA[31]|PRDATA[9]|PSLVERR|VGND
+ LO|PRDATA[10]|PRDATA[12]|PRDATA[13]|PRDATA[15]|PRDATA[16]|PRDATA[17]|PRDATA[18]|PRDATA[19]|PRDATA[21]|PRDATA[23]|PRDATA[27]|PRDATA[28]|PRDATA[29]|PRDATA[31]|PRDATA[9]|PSLVERR|VGND
+ sky130_fd_pr__nfet_01v8 L=0.15 W=0.42 AS=0.0669 AD=0.12495 PS=0.75 PD=1.015
M$1437
+ LO|PRDATA[10]|PRDATA[12]|PRDATA[13]|PRDATA[15]|PRDATA[16]|PRDATA[17]|PRDATA[18]|PRDATA[19]|PRDATA[21]|PRDATA[23]|PRDATA[27]|PRDATA[28]|PRDATA[29]|PRDATA[31]|PRDATA[9]|PSLVERR|VGND
+ PRESETn|RESET_B \$947
+ LO|PRDATA[10]|PRDATA[12]|PRDATA[13]|PRDATA[15]|PRDATA[16]|PRDATA[17]|PRDATA[18]|PRDATA[19]|PRDATA[21]|PRDATA[23]|PRDATA[27]|PRDATA[28]|PRDATA[29]|PRDATA[31]|PRDATA[9]|PSLVERR|VGND
+ sky130_fd_pr__nfet_01v8 L=0.15 W=0.42 AS=0.12495 AD=0.06405 PS=1.015 PD=0.725
M$1438 \$947 \$914 \$915
+ LO|PRDATA[10]|PRDATA[12]|PRDATA[13]|PRDATA[15]|PRDATA[16]|PRDATA[17]|PRDATA[18]|PRDATA[19]|PRDATA[21]|PRDATA[23]|PRDATA[27]|PRDATA[28]|PRDATA[29]|PRDATA[31]|PRDATA[9]|PSLVERR|VGND
+ sky130_fd_pr__nfet_01v8 L=0.15 W=0.42 AS=0.06405 AD=0.1092 PS=0.725 PD=1.36
M$1439 B|Y A0|C1|Q|gpio_out[7] \$950
+ LO|PRDATA[10]|PRDATA[12]|PRDATA[13]|PRDATA[15]|PRDATA[16]|PRDATA[17]|PRDATA[18]|PRDATA[19]|PRDATA[21]|PRDATA[23]|PRDATA[27]|PRDATA[28]|PRDATA[29]|PRDATA[31]|PRDATA[9]|PSLVERR|VGND
+ sky130_fd_pr__nfet_01v8 L=0.15 W=0.64 AS=0.1664 AD=0.0672 PS=1.8 PD=0.85
M$1440 \$950 A2|B|C2|Y
+ LO|PRDATA[10]|PRDATA[12]|PRDATA[13]|PRDATA[15]|PRDATA[16]|PRDATA[17]|PRDATA[18]|PRDATA[19]|PRDATA[21]|PRDATA[23]|PRDATA[27]|PRDATA[28]|PRDATA[29]|PRDATA[31]|PRDATA[9]|PSLVERR|VGND
+ LO|PRDATA[10]|PRDATA[12]|PRDATA[13]|PRDATA[15]|PRDATA[16]|PRDATA[17]|PRDATA[18]|PRDATA[19]|PRDATA[21]|PRDATA[23]|PRDATA[27]|PRDATA[28]|PRDATA[29]|PRDATA[31]|PRDATA[9]|PSLVERR|VGND
+ sky130_fd_pr__nfet_01v8 L=0.15 W=0.64 AS=0.0672 AD=0.2912 PS=0.85 PD=1.55
M$1441
+ LO|PRDATA[10]|PRDATA[12]|PRDATA[13]|PRDATA[15]|PRDATA[16]|PRDATA[17]|PRDATA[18]|PRDATA[19]|PRDATA[21]|PRDATA[23]|PRDATA[27]|PRDATA[28]|PRDATA[29]|PRDATA[31]|PRDATA[9]|PSLVERR|VGND
+ A0|B2|Q|gpio_oe[7] \$948
+ LO|PRDATA[10]|PRDATA[12]|PRDATA[13]|PRDATA[15]|PRDATA[16]|PRDATA[17]|PRDATA[18]|PRDATA[19]|PRDATA[21]|PRDATA[23]|PRDATA[27]|PRDATA[28]|PRDATA[29]|PRDATA[31]|PRDATA[9]|PSLVERR|VGND
+ sky130_fd_pr__nfet_01v8 L=0.15 W=0.64 AS=0.2912 AD=0.0672 PS=1.55 PD=0.85
M$1442 \$948 B|B1|B_N|Y B|Y
+ LO|PRDATA[10]|PRDATA[12]|PRDATA[13]|PRDATA[15]|PRDATA[16]|PRDATA[17]|PRDATA[18]|PRDATA[19]|PRDATA[21]|PRDATA[23]|PRDATA[27]|PRDATA[28]|PRDATA[29]|PRDATA[31]|PRDATA[9]|PSLVERR|VGND
+ sky130_fd_pr__nfet_01v8 L=0.15 W=0.64 AS=0.0672 AD=0.1056 PS=0.85 PD=0.97
M$1443 B|Y A1|gpio_in[7] \$946
+ LO|PRDATA[10]|PRDATA[12]|PRDATA[13]|PRDATA[15]|PRDATA[16]|PRDATA[17]|PRDATA[18]|PRDATA[19]|PRDATA[21]|PRDATA[23]|PRDATA[27]|PRDATA[28]|PRDATA[29]|PRDATA[31]|PRDATA[9]|PSLVERR|VGND
+ sky130_fd_pr__nfet_01v8 L=0.15 W=0.64 AS=0.1056 AD=0.1056 PS=0.97 PD=0.97
M$1444 \$946 A2|B1|Y
+ LO|PRDATA[10]|PRDATA[12]|PRDATA[13]|PRDATA[15]|PRDATA[16]|PRDATA[17]|PRDATA[18]|PRDATA[19]|PRDATA[21]|PRDATA[23]|PRDATA[27]|PRDATA[28]|PRDATA[29]|PRDATA[31]|PRDATA[9]|PSLVERR|VGND
+ LO|PRDATA[10]|PRDATA[12]|PRDATA[13]|PRDATA[15]|PRDATA[16]|PRDATA[17]|PRDATA[18]|PRDATA[19]|PRDATA[21]|PRDATA[23]|PRDATA[27]|PRDATA[28]|PRDATA[29]|PRDATA[31]|PRDATA[9]|PSLVERR|VGND
+ sky130_fd_pr__nfet_01v8 L=0.15 W=0.64 AS=0.1056 AD=0.1664 PS=0.97 PD=1.8
M$1445 B|Y A0|C1|Q|gpio_out[5] \$939
+ LO|PRDATA[10]|PRDATA[12]|PRDATA[13]|PRDATA[15]|PRDATA[16]|PRDATA[17]|PRDATA[18]|PRDATA[19]|PRDATA[21]|PRDATA[23]|PRDATA[27]|PRDATA[28]|PRDATA[29]|PRDATA[31]|PRDATA[9]|PSLVERR|VGND
+ sky130_fd_pr__nfet_01v8 L=0.15 W=0.64 AS=0.1664 AD=0.0672 PS=1.8 PD=0.85
M$1446 \$939 A2|B|C2|Y
+ LO|PRDATA[10]|PRDATA[12]|PRDATA[13]|PRDATA[15]|PRDATA[16]|PRDATA[17]|PRDATA[18]|PRDATA[19]|PRDATA[21]|PRDATA[23]|PRDATA[27]|PRDATA[28]|PRDATA[29]|PRDATA[31]|PRDATA[9]|PSLVERR|VGND
+ LO|PRDATA[10]|PRDATA[12]|PRDATA[13]|PRDATA[15]|PRDATA[16]|PRDATA[17]|PRDATA[18]|PRDATA[19]|PRDATA[21]|PRDATA[23]|PRDATA[27]|PRDATA[28]|PRDATA[29]|PRDATA[31]|PRDATA[9]|PSLVERR|VGND
+ sky130_fd_pr__nfet_01v8 L=0.15 W=0.64 AS=0.0672 AD=0.2912 PS=0.85 PD=1.55
M$1447
+ LO|PRDATA[10]|PRDATA[12]|PRDATA[13]|PRDATA[15]|PRDATA[16]|PRDATA[17]|PRDATA[18]|PRDATA[19]|PRDATA[21]|PRDATA[23]|PRDATA[27]|PRDATA[28]|PRDATA[29]|PRDATA[31]|PRDATA[9]|PSLVERR|VGND
+ A0|B2|Q|gpio_oe[5] \$937
+ LO|PRDATA[10]|PRDATA[12]|PRDATA[13]|PRDATA[15]|PRDATA[16]|PRDATA[17]|PRDATA[18]|PRDATA[19]|PRDATA[21]|PRDATA[23]|PRDATA[27]|PRDATA[28]|PRDATA[29]|PRDATA[31]|PRDATA[9]|PSLVERR|VGND
+ sky130_fd_pr__nfet_01v8 L=0.15 W=0.64 AS=0.2912 AD=0.0672 PS=1.55 PD=0.85
M$1448 \$937 B|B1|B_N|Y B|Y
+ LO|PRDATA[10]|PRDATA[12]|PRDATA[13]|PRDATA[15]|PRDATA[16]|PRDATA[17]|PRDATA[18]|PRDATA[19]|PRDATA[21]|PRDATA[23]|PRDATA[27]|PRDATA[28]|PRDATA[29]|PRDATA[31]|PRDATA[9]|PSLVERR|VGND
+ sky130_fd_pr__nfet_01v8 L=0.15 W=0.64 AS=0.0672 AD=0.1056 PS=0.85 PD=0.97
M$1449 B|Y A1|gpio_in[5] \$936
+ LO|PRDATA[10]|PRDATA[12]|PRDATA[13]|PRDATA[15]|PRDATA[16]|PRDATA[17]|PRDATA[18]|PRDATA[19]|PRDATA[21]|PRDATA[23]|PRDATA[27]|PRDATA[28]|PRDATA[29]|PRDATA[31]|PRDATA[9]|PSLVERR|VGND
+ sky130_fd_pr__nfet_01v8 L=0.15 W=0.64 AS=0.1056 AD=0.1056 PS=0.97 PD=0.97
M$1450 \$936 A2|B1|Y
+ LO|PRDATA[10]|PRDATA[12]|PRDATA[13]|PRDATA[15]|PRDATA[16]|PRDATA[17]|PRDATA[18]|PRDATA[19]|PRDATA[21]|PRDATA[23]|PRDATA[27]|PRDATA[28]|PRDATA[29]|PRDATA[31]|PRDATA[9]|PSLVERR|VGND
+ LO|PRDATA[10]|PRDATA[12]|PRDATA[13]|PRDATA[15]|PRDATA[16]|PRDATA[17]|PRDATA[18]|PRDATA[19]|PRDATA[21]|PRDATA[23]|PRDATA[27]|PRDATA[28]|PRDATA[29]|PRDATA[31]|PRDATA[9]|PSLVERR|VGND
+ sky130_fd_pr__nfet_01v8 L=0.15 W=0.64 AS=0.1056 AD=0.1664 PS=0.97 PD=1.8
M$1451
+ LO|PRDATA[10]|PRDATA[12]|PRDATA[13]|PRDATA[15]|PRDATA[16]|PRDATA[17]|PRDATA[18]|PRDATA[19]|PRDATA[21]|PRDATA[23]|PRDATA[27]|PRDATA[28]|PRDATA[29]|PRDATA[31]|PRDATA[9]|PSLVERR|VGND
+ A|X PRDATA[7]|Y
+ LO|PRDATA[10]|PRDATA[12]|PRDATA[13]|PRDATA[15]|PRDATA[16]|PRDATA[17]|PRDATA[18]|PRDATA[19]|PRDATA[21]|PRDATA[23]|PRDATA[27]|PRDATA[28]|PRDATA[29]|PRDATA[31]|PRDATA[9]|PSLVERR|VGND
+ sky130_fd_pr__nfet_01v8 L=0.15 W=1.3 AS=0.26975 AD=0.1755 PS=2.78 PD=1.84
M$1453
+ LO|PRDATA[10]|PRDATA[12]|PRDATA[13]|PRDATA[15]|PRDATA[16]|PRDATA[17]|PRDATA[18]|PRDATA[19]|PRDATA[21]|PRDATA[23]|PRDATA[27]|PRDATA[28]|PRDATA[29]|PRDATA[31]|PRDATA[9]|PSLVERR|VGND
+ B|Y PRDATA[7]|Y
+ LO|PRDATA[10]|PRDATA[12]|PRDATA[13]|PRDATA[15]|PRDATA[16]|PRDATA[17]|PRDATA[18]|PRDATA[19]|PRDATA[21]|PRDATA[23]|PRDATA[27]|PRDATA[28]|PRDATA[29]|PRDATA[31]|PRDATA[9]|PSLVERR|VGND
+ sky130_fd_pr__nfet_01v8 L=0.15 W=1.3 AS=0.1755 AD=0.25675 PS=1.84 PD=2.74
M$1455
+ LO|PRDATA[10]|PRDATA[12]|PRDATA[13]|PRDATA[15]|PRDATA[16]|PRDATA[17]|PRDATA[18]|PRDATA[19]|PRDATA[21]|PRDATA[23]|PRDATA[27]|PRDATA[28]|PRDATA[29]|PRDATA[31]|PRDATA[9]|PSLVERR|VGND
+ A|X PRDATA[5]|Y
+ LO|PRDATA[10]|PRDATA[12]|PRDATA[13]|PRDATA[15]|PRDATA[16]|PRDATA[17]|PRDATA[18]|PRDATA[19]|PRDATA[21]|PRDATA[23]|PRDATA[27]|PRDATA[28]|PRDATA[29]|PRDATA[31]|PRDATA[9]|PSLVERR|VGND
+ sky130_fd_pr__nfet_01v8 L=0.15 W=1.3 AS=0.26975 AD=0.1755 PS=2.78 PD=1.84
M$1457
+ LO|PRDATA[10]|PRDATA[12]|PRDATA[13]|PRDATA[15]|PRDATA[16]|PRDATA[17]|PRDATA[18]|PRDATA[19]|PRDATA[21]|PRDATA[23]|PRDATA[27]|PRDATA[28]|PRDATA[29]|PRDATA[31]|PRDATA[9]|PSLVERR|VGND
+ B|Y PRDATA[5]|Y
+ LO|PRDATA[10]|PRDATA[12]|PRDATA[13]|PRDATA[15]|PRDATA[16]|PRDATA[17]|PRDATA[18]|PRDATA[19]|PRDATA[21]|PRDATA[23]|PRDATA[27]|PRDATA[28]|PRDATA[29]|PRDATA[31]|PRDATA[9]|PSLVERR|VGND
+ sky130_fd_pr__nfet_01v8 L=0.15 W=1.3 AS=0.1755 AD=0.25675 PS=1.84 PD=2.74
.ENDS apb_gpio
